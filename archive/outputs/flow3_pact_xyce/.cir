.title spice solver
Vg GND 0 318.15
I_0_0_0 GND Node0_0_0 4.0814260000000044e-05A
R_0_0_0_1 Node0_0_0 Node0_0_1 76.99999999999991
R_0_0_0_2 Node0_0_0 Node0_1_0 76.99999999999991
R_0_0_0_3 Node0_0_0 Node1_0_0 3153.9199999999973
I_0_0_1 GND Node0_0_1 4.0814260000000044e-05A
R_0_0_1_1 Node0_0_1 Node0_0_2 76.99999999999991
R_0_0_1_2 Node0_0_1 Node0_1_1 76.99999999999991
R_0_0_1_3 Node0_0_1 Node1_0_1 3153.9199999999973
I_0_0_2 GND Node0_0_2 4.0814260000000044e-05A
R_0_0_2_1 Node0_0_2 Node0_0_3 76.99999999999991
R_0_0_2_2 Node0_0_2 Node0_1_2 76.99999999999991
R_0_0_2_3 Node0_0_2 Node1_0_2 3153.9199999999973
I_0_0_3 GND Node0_0_3 4.0814260000000044e-05A
R_0_0_3_1 Node0_0_3 Node0_0_4 76.99999999999991
R_0_0_3_2 Node0_0_3 Node0_1_3 76.99999999999991
R_0_0_3_3 Node0_0_3 Node1_0_3 3153.9199999999973
I_0_0_4 GND Node0_0_4 4.0814260000000044e-05A
R_0_0_4_1 Node0_0_4 Node0_0_5 76.99999999999991
R_0_0_4_2 Node0_0_4 Node0_1_4 76.99999999999991
R_0_0_4_3 Node0_0_4 Node1_0_4 3153.9199999999973
I_0_0_5 GND Node0_0_5 4.0814260000000044e-05A
R_0_0_5_1 Node0_0_5 Node0_0_6 76.99999999999991
R_0_0_5_2 Node0_0_5 Node0_1_5 76.99999999999991
R_0_0_5_3 Node0_0_5 Node1_0_5 3153.9199999999973
I_0_0_6 GND Node0_0_6 4.0814260000000044e-05A
R_0_0_6_1 Node0_0_6 Node0_0_7 76.99999999999991
R_0_0_6_2 Node0_0_6 Node0_1_6 76.99999999999991
R_0_0_6_3 Node0_0_6 Node1_0_6 3153.9199999999973
I_0_0_7 GND Node0_0_7 4.0814260000000044e-05A
R_0_0_7_1 Node0_0_7 Node0_0_8 76.99999999999989
R_0_0_7_2 Node0_0_7 Node0_1_7 76.99999999999991
R_0_0_7_3 Node0_0_7 Node1_0_7 3153.9199999999973
I_0_0_8 GND Node0_0_8 4.081427000000008e-05A
R_0_0_8_1 Node0_0_8 Node0_0_9 76.99999999999984
R_0_0_8_2 Node0_0_8 Node0_1_8 76.99999999999984
R_0_0_8_3 Node0_0_8 Node1_0_8 3153.919999999994
I_0_0_9 GND Node0_0_9 4.081427000000008e-05A
R_0_0_9_1 Node0_0_9 Node0_0_10 76.99999999999991
R_0_0_9_2 Node0_0_9 Node0_1_9 76.99999999999984
R_0_0_9_3 Node0_0_9 Node1_0_9 3153.919999999994
I_0_0_10 GND Node0_0_10 4.081428e-05A
R_0_0_10_1 Node0_0_10 Node0_0_11 76.99999999999991
R_0_0_10_2 Node0_0_10 Node0_1_10 77.0
R_0_0_10_3 Node0_0_10 Node1_0_10 3153.9200000000005
I_0_0_11 GND Node0_0_11 4.081429000000008e-05A
R_0_0_11_1 Node0_0_11 Node0_0_12 76.99999999999984
R_0_0_11_2 Node0_0_11 Node0_1_11 76.99999999999984
R_0_0_11_3 Node0_0_11 Node1_0_11 3153.919999999994
I_0_0_12 GND Node0_0_12 4.0814310000000075e-05A
R_0_0_12_1 Node0_0_12 Node0_0_13 76.99999999999984
R_0_0_12_2 Node0_0_12 Node0_1_12 76.99999999999984
R_0_0_12_3 Node0_0_12 Node1_0_12 3153.919999999994
I_0_0_13 GND Node0_0_13 4.0814340000000084e-05A
R_0_0_13_1 Node0_0_13 Node0_0_14 76.99999999999991
R_0_0_13_2 Node0_0_13 Node0_1_13 76.99999999999984
R_0_0_13_3 Node0_0_13 Node1_0_13 3153.919999999994
I_0_0_14 GND Node0_0_14 4.081436e-05A
R_0_0_14_1 Node0_0_14 Node0_0_15 76.99999999999991
R_0_0_14_2 Node0_0_14 Node0_1_14 77.0
R_0_0_14_3 Node0_0_14 Node1_0_14 3153.9200000000005
I_0_0_15 GND Node0_0_15 4.081438000000008e-05A
R_0_0_15_1 Node0_0_15 Node0_0_16 76.99999999999984
R_0_0_15_2 Node0_0_15 Node0_1_15 76.99999999999984
R_0_0_15_3 Node0_0_15 Node1_0_15 3153.919999999994
I_0_0_16 GND Node0_0_16 4.081439000000008e-05A
R_0_0_16_1 Node0_0_16 Node0_0_17 76.99999999999984
R_0_0_16_2 Node0_0_16 Node0_1_16 76.99999999999984
R_0_0_16_3 Node0_0_16 Node1_0_16 3153.919999999994
I_0_0_17 GND Node0_0_17 4.081438000000008e-05A
R_0_0_17_1 Node0_0_17 Node0_0_18 76.99999999999984
R_0_0_17_2 Node0_0_17 Node0_1_17 76.99999999999984
R_0_0_17_3 Node0_0_17 Node1_0_17 3153.919999999994
I_0_0_18 GND Node0_0_18 4.081436000000008e-05A
R_0_0_18_1 Node0_0_18 Node0_0_19 76.99999999999984
R_0_0_18_2 Node0_0_18 Node0_1_18 76.99999999999984
R_0_0_18_3 Node0_0_18 Node1_0_18 3153.919999999994
I_0_0_19 GND Node0_0_19 4.0814340000000084e-05A
R_0_0_19_1 Node0_0_19 Node0_0_20 76.99999999999984
R_0_0_19_2 Node0_0_19 Node0_1_19 76.99999999999984
R_0_0_19_3 Node0_0_19 Node1_0_19 3153.919999999994
I_0_0_20 GND Node0_0_20 4.0814310000000075e-05A
R_0_0_20_1 Node0_0_20 Node0_0_21 76.99999999999997
R_0_0_20_2 Node0_0_20 Node0_1_20 76.99999999999984
R_0_0_20_3 Node0_0_20 Node1_0_20 3153.919999999994
I_0_0_21 GND Node0_0_21 4.081428999999993e-05A
R_0_0_21_1 Node0_0_21 Node0_0_22 76.99999999999997
R_0_0_21_2 Node0_0_21 Node0_1_21 77.00000000000011
R_0_0_21_3 Node0_0_21 Node1_0_21 3153.920000000006
I_0_0_22 GND Node0_0_22 4.081428000000008e-05A
R_0_0_22_1 Node0_0_22 Node0_0_23 76.99999999999984
R_0_0_22_2 Node0_0_22 Node0_1_22 76.99999999999984
R_0_0_22_3 Node0_0_22 Node1_0_22 3153.919999999994
I_0_0_23 GND Node0_0_23 4.081427000000008e-05A
R_0_0_23_1 Node0_0_23 Node0_0_24 76.99999999999984
R_0_0_23_2 Node0_0_23 Node0_1_23 76.99999999999984
R_0_0_23_3 Node0_0_23 Node1_0_23 3153.919999999994
I_0_0_24 GND Node0_0_24 4.081427000000008e-05A
R_0_0_24_1 Node0_0_24 Node0_0_25 76.99999999999984
R_0_0_24_2 Node0_0_24 Node0_1_24 76.99999999999984
R_0_0_24_3 Node0_0_24 Node1_0_24 3153.919999999994
I_0_0_25 GND Node0_0_25 4.081426000000008e-05A
R_0_0_25_1 Node0_0_25 Node0_0_26 76.99999999999984
R_0_0_25_2 Node0_0_25 Node0_1_25 76.99999999999984
R_0_0_25_3 Node0_0_25 Node1_0_25 3153.919999999994
I_0_0_26 GND Node0_0_26 4.081426000000008e-05A
R_0_0_26_1 Node0_0_26 Node0_0_27 76.99999999999984
R_0_0_26_2 Node0_0_26 Node0_1_26 76.99999999999984
R_0_0_26_3 Node0_0_26 Node1_0_26 3153.919999999994
I_0_0_27 GND Node0_0_27 4.081426000000008e-05A
R_0_0_27_1 Node0_0_27 Node0_0_28 76.99999999999984
R_0_0_27_2 Node0_0_27 Node0_1_27 76.99999999999984
R_0_0_27_3 Node0_0_27 Node1_0_27 3153.919999999994
I_0_0_28 GND Node0_0_28 4.081426000000008e-05A
R_0_0_28_1 Node0_0_28 Node0_0_29 76.99999999999997
R_0_0_28_2 Node0_0_28 Node0_1_28 76.99999999999984
R_0_0_28_3 Node0_0_28 Node1_0_28 3153.919999999994
I_0_0_29 GND Node0_0_29 4.081425999999993e-05A
R_0_0_29_1 Node0_0_29 Node0_0_30 76.99999999999997
R_0_0_29_2 Node0_0_29 Node0_1_29 77.00000000000011
R_0_0_29_3 Node0_0_29 Node1_0_29 3153.920000000006
I_0_0_30 GND Node0_0_30 4.081426000000008e-05A
R_0_0_30_1 Node0_0_30 Node0_0_31 76.99999999999984
R_0_0_30_2 Node0_0_30 Node0_1_30 76.99999999999984
R_0_0_30_3 Node0_0_30 Node1_0_30 3153.919999999994
I_0_0_31 GND Node0_0_31 4.081426000000008e-05A
R_0_0_31_2 Node0_0_31 Node0_1_31 76.99999999999984
R_0_0_31_3 Node0_0_31 Node1_0_31 3153.919999999994
I_0_1_0 GND Node0_1_0 4.0814260000000044e-05A
R_0_1_0_1 Node0_1_0 Node0_1_1 76.99999999999991
R_0_1_0_2 Node0_1_0 Node0_2_0 77.00000000000006
R_0_1_0_3 Node0_1_0 Node1_1_0 3153.9199999999973
I_0_1_1 GND Node0_1_1 4.0814260000000044e-05A
R_0_1_1_1 Node0_1_1 Node0_1_2 76.99999999999991
R_0_1_1_2 Node0_1_1 Node0_2_1 77.00000000000006
R_0_1_1_3 Node0_1_1 Node1_1_1 3153.9199999999973
I_0_1_2 GND Node0_1_2 4.0814260000000044e-05A
R_0_1_2_1 Node0_1_2 Node0_1_3 76.99999999999991
R_0_1_2_2 Node0_1_2 Node0_2_2 77.00000000000006
R_0_1_2_3 Node0_1_2 Node1_1_2 3153.9199999999973
I_0_1_3 GND Node0_1_3 4.0814260000000044e-05A
R_0_1_3_1 Node0_1_3 Node0_1_4 76.99999999999991
R_0_1_3_2 Node0_1_3 Node0_2_3 77.00000000000006
R_0_1_3_3 Node0_1_3 Node1_1_3 3153.9199999999973
I_0_1_4 GND Node0_1_4 4.0814260000000044e-05A
R_0_1_4_1 Node0_1_4 Node0_1_5 76.99999999999991
R_0_1_4_2 Node0_1_4 Node0_2_4 77.00000000000006
R_0_1_4_3 Node0_1_4 Node1_1_4 3153.9199999999973
I_0_1_5 GND Node0_1_5 4.0814260000000044e-05A
R_0_1_5_1 Node0_1_5 Node0_1_6 76.99999999999991
R_0_1_5_2 Node0_1_5 Node0_2_5 77.00000000000006
R_0_1_5_3 Node0_1_5 Node1_1_5 3153.9199999999973
I_0_1_6 GND Node0_1_6 4.0814260000000044e-05A
R_0_1_6_1 Node0_1_6 Node0_1_7 76.99999999999991
R_0_1_6_2 Node0_1_6 Node0_2_6 77.00000000000006
R_0_1_6_3 Node0_1_6 Node1_1_6 3153.9199999999973
I_0_1_7 GND Node0_1_7 4.0814270000000045e-05A
R_0_1_7_1 Node0_1_7 Node0_1_8 76.99999999999989
R_0_1_7_2 Node0_1_7 Node0_2_7 77.00000000000006
R_0_1_7_3 Node0_1_7 Node1_1_7 3153.9199999999973
I_0_1_8 GND Node0_1_8 4.081428000000008e-05A
R_0_1_8_1 Node0_1_8 Node0_1_9 76.99999999999984
R_0_1_8_2 Node0_1_8 Node0_2_8 76.99999999999997
R_0_1_8_3 Node0_1_8 Node1_1_8 3153.919999999994
I_0_1_9 GND Node0_1_9 4.081430000000008e-05A
R_0_1_9_1 Node0_1_9 Node0_1_10 76.99999999999991
R_0_1_9_2 Node0_1_9 Node0_2_9 76.99999999999997
R_0_1_9_3 Node0_1_9 Node1_1_9 3153.919999999994
I_0_1_10 GND Node0_1_10 4.081435e-05A
R_0_1_10_1 Node0_1_10 Node0_1_11 76.99999999999991
R_0_1_10_2 Node0_1_10 Node0_2_10 77.00000000000013
R_0_1_10_3 Node0_1_10 Node1_1_10 3153.9200000000005
I_0_1_11 GND Node0_1_11 4.0814430000000083e-05A
R_0_1_11_1 Node0_1_11 Node0_1_12 76.99999999999984
R_0_1_11_2 Node0_1_11 Node0_2_11 76.99999999999997
R_0_1_11_3 Node0_1_11 Node1_1_11 3153.919999999994
I_0_1_12 GND Node0_1_12 4.081455000000008e-05A
R_0_1_12_1 Node0_1_12 Node0_1_13 76.99999999999984
R_0_1_12_2 Node0_1_12 Node0_2_12 76.99999999999997
R_0_1_12_3 Node0_1_12 Node1_1_12 3153.919999999994
I_0_1_13 GND Node0_1_13 4.081471000000008e-05A
R_0_1_13_1 Node0_1_13 Node0_1_14 76.99999999999991
R_0_1_13_2 Node0_1_13 Node0_2_13 76.99999999999997
R_0_1_13_3 Node0_1_13 Node1_1_13 3153.919999999994
I_0_1_14 GND Node0_1_14 4.081487e-05A
R_0_1_14_1 Node0_1_14 Node0_1_15 76.99999999999991
R_0_1_14_2 Node0_1_14 Node0_2_14 77.00000000000013
R_0_1_14_3 Node0_1_14 Node1_1_14 3153.9200000000005
I_0_1_15 GND Node0_1_15 4.081500000000008e-05A
R_0_1_15_1 Node0_1_15 Node0_1_16 76.99999999999984
R_0_1_15_2 Node0_1_15 Node0_2_15 76.99999999999997
R_0_1_15_3 Node0_1_15 Node1_1_15 3153.919999999994
I_0_1_16 GND Node0_1_16 4.081504000000008e-05A
R_0_1_16_1 Node0_1_16 Node0_1_17 76.99999999999984
R_0_1_16_2 Node0_1_16 Node0_2_16 76.99999999999997
R_0_1_16_3 Node0_1_16 Node1_1_16 3153.919999999994
I_0_1_17 GND Node0_1_17 4.081500000000008e-05A
R_0_1_17_1 Node0_1_17 Node0_1_18 76.99999999999984
R_0_1_17_2 Node0_1_17 Node0_2_17 76.99999999999997
R_0_1_17_3 Node0_1_17 Node1_1_17 3153.919999999994
I_0_1_18 GND Node0_1_18 4.081487000000008e-05A
R_0_1_18_1 Node0_1_18 Node0_1_19 76.99999999999984
R_0_1_18_2 Node0_1_18 Node0_2_18 76.99999999999997
R_0_1_18_3 Node0_1_18 Node1_1_18 3153.919999999994
I_0_1_19 GND Node0_1_19 4.081471000000008e-05A
R_0_1_19_1 Node0_1_19 Node0_1_20 76.99999999999984
R_0_1_19_2 Node0_1_19 Node0_2_19 76.99999999999997
R_0_1_19_3 Node0_1_19 Node1_1_19 3153.919999999994
I_0_1_20 GND Node0_1_20 4.081455000000008e-05A
R_0_1_20_1 Node0_1_20 Node0_1_21 76.99999999999997
R_0_1_20_2 Node0_1_20 Node0_2_20 76.99999999999997
R_0_1_20_3 Node0_1_20 Node1_1_20 3153.919999999994
I_0_1_21 GND Node0_1_21 4.0814429999999934e-05A
R_0_1_21_1 Node0_1_21 Node0_1_22 76.99999999999997
R_0_1_21_2 Node0_1_21 Node0_2_21 77.00000000000026
R_0_1_21_3 Node0_1_21 Node1_1_21 3153.920000000006
I_0_1_22 GND Node0_1_22 4.0814350000000085e-05A
R_0_1_22_1 Node0_1_22 Node0_1_23 76.99999999999984
R_0_1_22_2 Node0_1_22 Node0_2_22 76.99999999999997
R_0_1_22_3 Node0_1_22 Node1_1_22 3153.919999999994
I_0_1_23 GND Node0_1_23 4.081430000000008e-05A
R_0_1_23_1 Node0_1_23 Node0_1_24 76.99999999999984
R_0_1_23_2 Node0_1_23 Node0_2_23 76.99999999999997
R_0_1_23_3 Node0_1_23 Node1_1_23 3153.919999999994
I_0_1_24 GND Node0_1_24 4.081428000000008e-05A
R_0_1_24_1 Node0_1_24 Node0_1_25 76.99999999999984
R_0_1_24_2 Node0_1_24 Node0_2_24 76.99999999999997
R_0_1_24_3 Node0_1_24 Node1_1_24 3153.919999999994
I_0_1_25 GND Node0_1_25 4.081427000000008e-05A
R_0_1_25_1 Node0_1_25 Node0_1_26 76.99999999999984
R_0_1_25_2 Node0_1_25 Node0_2_25 76.99999999999997
R_0_1_25_3 Node0_1_25 Node1_1_25 3153.919999999994
I_0_1_26 GND Node0_1_26 4.081426000000008e-05A
R_0_1_26_1 Node0_1_26 Node0_1_27 76.99999999999984
R_0_1_26_2 Node0_1_26 Node0_2_26 76.99999999999997
R_0_1_26_3 Node0_1_26 Node1_1_26 3153.919999999994
I_0_1_27 GND Node0_1_27 4.081426000000008e-05A
R_0_1_27_1 Node0_1_27 Node0_1_28 76.99999999999984
R_0_1_27_2 Node0_1_27 Node0_2_27 76.99999999999997
R_0_1_27_3 Node0_1_27 Node1_1_27 3153.919999999994
I_0_1_28 GND Node0_1_28 4.081426000000008e-05A
R_0_1_28_1 Node0_1_28 Node0_1_29 76.99999999999997
R_0_1_28_2 Node0_1_28 Node0_2_28 76.99999999999997
R_0_1_28_3 Node0_1_28 Node1_1_28 3153.919999999994
I_0_1_29 GND Node0_1_29 4.081425999999993e-05A
R_0_1_29_1 Node0_1_29 Node0_1_30 76.99999999999997
R_0_1_29_2 Node0_1_29 Node0_2_29 77.00000000000026
R_0_1_29_3 Node0_1_29 Node1_1_29 3153.920000000006
I_0_1_30 GND Node0_1_30 4.081426000000008e-05A
R_0_1_30_1 Node0_1_30 Node0_1_31 76.99999999999984
R_0_1_30_2 Node0_1_30 Node0_2_30 76.99999999999997
R_0_1_30_3 Node0_1_30 Node1_1_30 3153.919999999994
I_0_1_31 GND Node0_1_31 4.081426000000008e-05A
R_0_1_31_2 Node0_1_31 Node0_2_31 76.99999999999997
R_0_1_31_3 Node0_1_31 Node1_1_31 3153.919999999994
I_0_2_0 GND Node0_2_0 4.0814259999999895e-05A
R_0_2_0_1 Node0_2_0 Node0_2_1 77.00000000000018
R_0_2_0_2 Node0_2_0 Node0_3_0 77.00000000000006
R_0_2_0_3 Node0_2_0 Node1_2_0 3153.9200000000087
I_0_2_1 GND Node0_2_1 4.0814259999999895e-05A
R_0_2_1_1 Node0_2_1 Node0_2_2 77.00000000000018
R_0_2_1_2 Node0_2_1 Node0_3_1 77.00000000000006
R_0_2_1_3 Node0_2_1 Node1_2_1 3153.9200000000087
I_0_2_2 GND Node0_2_2 4.0814259999999895e-05A
R_0_2_2_1 Node0_2_2 Node0_2_3 77.00000000000018
R_0_2_2_2 Node0_2_2 Node0_3_2 77.00000000000006
R_0_2_2_3 Node0_2_2 Node1_2_2 3153.9200000000087
I_0_2_3 GND Node0_2_3 4.0814259999999895e-05A
R_0_2_3_1 Node0_2_3 Node0_2_4 77.00000000000018
R_0_2_3_2 Node0_2_3 Node0_3_3 77.00000000000006
R_0_2_3_3 Node0_2_3 Node1_2_3 3153.9200000000087
I_0_2_4 GND Node0_2_4 4.0814259999999895e-05A
R_0_2_4_1 Node0_2_4 Node0_2_5 77.00000000000018
R_0_2_4_2 Node0_2_4 Node0_3_4 77.00000000000006
R_0_2_4_3 Node0_2_4 Node1_2_4 3153.9200000000087
I_0_2_5 GND Node0_2_5 4.0814269999999896e-05A
R_0_2_5_1 Node0_2_5 Node0_2_6 77.00000000000018
R_0_2_5_2 Node0_2_5 Node0_3_5 77.00000000000006
R_0_2_5_3 Node0_2_5 Node1_2_5 3153.9200000000087
I_0_2_6 GND Node0_2_6 4.0814269999999896e-05A
R_0_2_6_1 Node0_2_6 Node0_2_7 77.00000000000018
R_0_2_6_2 Node0_2_6 Node0_3_6 77.00000000000006
R_0_2_6_3 Node0_2_6 Node1_2_6 3153.9200000000087
I_0_2_7 GND Node0_2_7 4.08142899999999e-05A
R_0_2_7_1 Node0_2_7 Node0_2_8 77.00000000000014
R_0_2_7_2 Node0_2_7 Node0_3_7 77.00000000000006
R_0_2_7_3 Node0_2_7 Node1_2_7 3153.9200000000087
I_0_2_8 GND Node0_2_8 4.0814339999999935e-05A
R_0_2_8_1 Node0_2_8 Node0_2_9 77.00000000000011
R_0_2_8_2 Node0_2_8 Node0_3_8 76.99999999999997
R_0_2_8_3 Node0_2_8 Node1_2_8 3153.920000000006
I_0_2_9 GND Node0_2_9 4.081445999999993e-05A
R_0_2_9_1 Node0_2_9 Node0_2_10 77.00000000000018
R_0_2_9_2 Node0_2_9 Node0_3_9 76.99999999999997
R_0_2_9_3 Node0_2_9 Node1_2_9 3153.920000000006
I_0_2_10 GND Node0_2_10 4.0814709999999866e-05A
R_0_2_10_1 Node0_2_10 Node0_2_11 77.00000000000018
R_0_2_10_2 Node0_2_10 Node0_3_10 77.00000000000013
R_0_2_10_3 Node0_2_10 Node1_2_10 3153.920000000011
I_0_2_11 GND Node0_2_11 4.081514999999993e-05A
R_0_2_11_1 Node0_2_11 Node0_2_12 77.00000000000011
R_0_2_11_2 Node0_2_11 Node0_3_11 76.99999999999997
R_0_2_11_3 Node0_2_11 Node1_2_11 3153.920000000006
I_0_2_12 GND Node0_2_12 4.081581999999993e-05A
R_0_2_12_1 Node0_2_12 Node0_2_13 77.00000000000011
R_0_2_12_2 Node0_2_12 Node0_3_12 76.99999999999997
R_0_2_12_3 Node0_2_12 Node1_2_12 3153.920000000006
I_0_2_13 GND Node0_2_13 4.0816669999999935e-05A
R_0_2_13_1 Node0_2_13 Node0_2_14 77.00000000000018
R_0_2_13_2 Node0_2_13 Node0_3_13 76.99999999999997
R_0_2_13_3 Node0_2_13 Node1_2_13 3153.920000000006
I_0_2_14 GND Node0_2_14 4.081754999999986e-05A
R_0_2_14_1 Node0_2_14 Node0_2_15 77.00000000000018
R_0_2_14_2 Node0_2_14 Node0_3_14 77.00000000000013
R_0_2_14_3 Node0_2_14 Node1_2_14 3153.920000000011
I_0_2_15 GND Node0_2_15 4.081822999999993e-05A
R_0_2_15_1 Node0_2_15 Node0_2_16 77.00000000000011
R_0_2_15_2 Node0_2_15 Node0_3_15 76.99999999999997
R_0_2_15_3 Node0_2_15 Node1_2_15 3153.920000000006
I_0_2_16 GND Node0_2_16 4.0818489999999934e-05A
R_0_2_16_1 Node0_2_16 Node0_2_17 77.00000000000011
R_0_2_16_2 Node0_2_16 Node0_3_16 76.99999999999997
R_0_2_16_3 Node0_2_16 Node1_2_16 3153.920000000006
I_0_2_17 GND Node0_2_17 4.081822999999993e-05A
R_0_2_17_1 Node0_2_17 Node0_2_18 77.00000000000011
R_0_2_17_2 Node0_2_17 Node0_3_17 76.99999999999997
R_0_2_17_3 Node0_2_17 Node1_2_17 3153.920000000006
I_0_2_18 GND Node0_2_18 4.081754999999993e-05A
R_0_2_18_1 Node0_2_18 Node0_2_19 77.00000000000011
R_0_2_18_2 Node0_2_18 Node0_3_18 76.99999999999997
R_0_2_18_3 Node0_2_18 Node1_2_18 3153.920000000006
I_0_2_19 GND Node0_2_19 4.0816669999999935e-05A
R_0_2_19_1 Node0_2_19 Node0_2_20 77.00000000000011
R_0_2_19_2 Node0_2_19 Node0_3_19 76.99999999999997
R_0_2_19_3 Node0_2_19 Node1_2_19 3153.920000000006
I_0_2_20 GND Node0_2_20 4.081581999999993e-05A
R_0_2_20_1 Node0_2_20 Node0_2_21 77.00000000000026
R_0_2_20_2 Node0_2_20 Node0_3_20 76.99999999999997
R_0_2_20_3 Node0_2_20 Node1_2_20 3153.920000000006
I_0_2_21 GND Node0_2_21 4.081514999999979e-05A
R_0_2_21_1 Node0_2_21 Node0_2_22 77.00000000000026
R_0_2_21_2 Node0_2_21 Node0_3_21 77.00000000000026
R_0_2_21_3 Node0_2_21 Node1_2_21 3153.920000000017
I_0_2_22 GND Node0_2_22 4.0814709999999934e-05A
R_0_2_22_1 Node0_2_22 Node0_2_23 77.00000000000011
R_0_2_22_2 Node0_2_22 Node0_3_22 76.99999999999997
R_0_2_22_3 Node0_2_22 Node1_2_22 3153.920000000006
I_0_2_23 GND Node0_2_23 4.081445999999993e-05A
R_0_2_23_1 Node0_2_23 Node0_2_24 77.00000000000011
R_0_2_23_2 Node0_2_23 Node0_3_23 76.99999999999997
R_0_2_23_3 Node0_2_23 Node1_2_23 3153.920000000006
I_0_2_24 GND Node0_2_24 4.0814339999999935e-05A
R_0_2_24_1 Node0_2_24 Node0_2_25 77.00000000000011
R_0_2_24_2 Node0_2_24 Node0_3_24 76.99999999999997
R_0_2_24_3 Node0_2_24 Node1_2_24 3153.920000000006
I_0_2_25 GND Node0_2_25 4.081428999999993e-05A
R_0_2_25_1 Node0_2_25 Node0_2_26 77.00000000000011
R_0_2_25_2 Node0_2_25 Node0_3_25 76.99999999999997
R_0_2_25_3 Node0_2_25 Node1_2_25 3153.920000000006
I_0_2_26 GND Node0_2_26 4.081426999999993e-05A
R_0_2_26_1 Node0_2_26 Node0_2_27 77.00000000000011
R_0_2_26_2 Node0_2_26 Node0_3_26 76.99999999999997
R_0_2_26_3 Node0_2_26 Node1_2_26 3153.920000000006
I_0_2_27 GND Node0_2_27 4.081426999999993e-05A
R_0_2_27_1 Node0_2_27 Node0_2_28 77.00000000000011
R_0_2_27_2 Node0_2_27 Node0_3_27 76.99999999999997
R_0_2_27_3 Node0_2_27 Node1_2_27 3153.920000000006
I_0_2_28 GND Node0_2_28 4.081425999999993e-05A
R_0_2_28_1 Node0_2_28 Node0_2_29 77.00000000000026
R_0_2_28_2 Node0_2_28 Node0_3_28 76.99999999999997
R_0_2_28_3 Node0_2_28 Node1_2_28 3153.920000000006
I_0_2_29 GND Node0_2_29 4.081425999999979e-05A
R_0_2_29_1 Node0_2_29 Node0_2_30 77.00000000000026
R_0_2_29_2 Node0_2_29 Node0_3_29 77.00000000000026
R_0_2_29_3 Node0_2_29 Node1_2_29 3153.920000000017
I_0_2_30 GND Node0_2_30 4.081425999999993e-05A
R_0_2_30_1 Node0_2_30 Node0_2_31 77.00000000000011
R_0_2_30_2 Node0_2_30 Node0_3_30 76.99999999999997
R_0_2_30_3 Node0_2_30 Node1_2_30 3153.920000000006
I_0_2_31 GND Node0_2_31 4.081425999999993e-05A
R_0_2_31_2 Node0_2_31 Node0_3_31 76.99999999999997
R_0_2_31_3 Node0_2_31 Node1_2_31 3153.920000000006
I_0_3_0 GND Node0_3_0 4.0814260000000044e-05A
R_0_3_0_1 Node0_3_0 Node0_3_1 76.99999999999991
R_0_3_0_2 Node0_3_0 Node0_4_0 76.99999999999991
R_0_3_0_3 Node0_3_0 Node1_3_0 3153.9199999999973
I_0_3_1 GND Node0_3_1 4.0814260000000044e-05A
R_0_3_1_1 Node0_3_1 Node0_3_2 76.99999999999991
R_0_3_1_2 Node0_3_1 Node0_4_1 76.99999999999991
R_0_3_1_3 Node0_3_1 Node1_3_1 3153.9199999999973
I_0_3_2 GND Node0_3_2 4.0814260000000044e-05A
R_0_3_2_1 Node0_3_2 Node0_3_3 76.99999999999991
R_0_3_2_2 Node0_3_2 Node0_4_2 76.99999999999991
R_0_3_2_3 Node0_3_2 Node1_3_2 3153.9199999999973
I_0_3_3 GND Node0_3_3 4.0814260000000044e-05A
R_0_3_3_1 Node0_3_3 Node0_3_4 76.99999999999991
R_0_3_3_2 Node0_3_3 Node0_4_3 76.99999999999991
R_0_3_3_3 Node0_3_3 Node1_3_3 3153.9199999999973
I_0_3_4 GND Node0_3_4 4.0814270000000045e-05A
R_0_3_4_1 Node0_3_4 Node0_3_5 76.99999999999991
R_0_3_4_2 Node0_3_4 Node0_4_4 76.99999999999991
R_0_3_4_3 Node0_3_4 Node1_3_4 3153.9199999999973
I_0_3_5 GND Node0_3_5 4.0814270000000045e-05A
R_0_3_5_1 Node0_3_5 Node0_3_6 76.99999999999991
R_0_3_5_2 Node0_3_5 Node0_4_5 76.99999999999991
R_0_3_5_3 Node0_3_5 Node1_3_5 3153.9199999999973
I_0_3_6 GND Node0_3_6 4.081430000000005e-05A
R_0_3_6_1 Node0_3_6 Node0_3_7 76.99999999999991
R_0_3_6_2 Node0_3_6 Node0_4_6 76.99999999999991
R_0_3_6_3 Node0_3_6 Node1_3_6 3153.9199999999973
I_0_3_7 GND Node0_3_7 4.081439000000005e-05A
R_0_3_7_1 Node0_3_7 Node0_3_8 76.99999999999989
R_0_3_7_2 Node0_3_7 Node0_4_7 76.99999999999991
R_0_3_7_3 Node0_3_7 Node1_3_7 3153.9199999999973
I_0_3_8 GND Node0_3_8 4.081463000000008e-05A
R_0_3_8_1 Node0_3_8 Node0_3_9 76.99999999999984
R_0_3_8_2 Node0_3_8 Node0_4_8 76.99999999999984
R_0_3_8_3 Node0_3_8 Node1_3_8 3153.919999999994
I_0_3_9 GND Node0_3_9 4.0815210000000084e-05A
R_0_3_9_1 Node0_3_9 Node0_3_10 76.99999999999991
R_0_3_9_2 Node0_3_9 Node0_4_9 76.99999999999984
R_0_3_9_3 Node0_3_9 Node1_3_9 3153.919999999994
I_0_3_10 GND Node0_3_10 4.081639e-05A
R_0_3_10_1 Node0_3_10 Node0_3_11 76.99999999999991
R_0_3_10_2 Node0_3_10 Node0_4_10 77.0
R_0_3_10_3 Node0_3_10 Node1_3_10 3153.9200000000005
I_0_3_11 GND Node0_3_11 4.081849000000008e-05A
R_0_3_11_1 Node0_3_11 Node0_3_12 76.99999999999984
R_0_3_11_2 Node0_3_11 Node0_4_11 76.99999999999984
R_0_3_11_3 Node0_3_11 Node1_3_11 3153.919999999994
I_0_3_12 GND Node0_3_12 4.082168000000008e-05A
R_0_3_12_1 Node0_3_12 Node0_3_13 76.99999999999984
R_0_3_12_2 Node0_3_12 Node0_4_12 76.99999999999984
R_0_3_12_3 Node0_3_12 Node1_3_12 3153.919999999994
I_0_3_13 GND Node0_3_13 4.082574000000008e-05A
R_0_3_13_1 Node0_3_13 Node0_3_14 76.99999999999991
R_0_3_13_2 Node0_3_13 Node0_4_13 76.99999999999984
R_0_3_13_3 Node0_3_13 Node1_3_13 3153.919999999994
I_0_3_14 GND Node0_3_14 4.082995e-05A
R_0_3_14_1 Node0_3_14 Node0_3_15 76.99999999999991
R_0_3_14_2 Node0_3_14 Node0_4_14 77.0
R_0_3_14_3 Node0_3_14 Node1_3_14 3153.9200000000005
I_0_3_15 GND Node0_3_15 4.083319000000008e-05A
R_0_3_15_1 Node0_3_15 Node0_3_16 76.99999999999984
R_0_3_15_2 Node0_3_15 Node0_4_15 76.99999999999984
R_0_3_15_3 Node0_3_15 Node1_3_15 3153.919999999994
I_0_3_16 GND Node0_3_16 4.083441000000008e-05A
R_0_3_16_1 Node0_3_16 Node0_3_17 76.99999999999984
R_0_3_16_2 Node0_3_16 Node0_4_16 76.99999999999984
R_0_3_16_3 Node0_3_16 Node1_3_16 3153.919999999994
I_0_3_17 GND Node0_3_17 4.083319000000008e-05A
R_0_3_17_1 Node0_3_17 Node0_3_18 76.99999999999984
R_0_3_17_2 Node0_3_17 Node0_4_17 76.99999999999984
R_0_3_17_3 Node0_3_17 Node1_3_17 3153.919999999994
I_0_3_18 GND Node0_3_18 4.082995000000008e-05A
R_0_3_18_1 Node0_3_18 Node0_3_19 76.99999999999984
R_0_3_18_2 Node0_3_18 Node0_4_18 76.99999999999984
R_0_3_18_3 Node0_3_18 Node1_3_18 3153.919999999994
I_0_3_19 GND Node0_3_19 4.082574000000008e-05A
R_0_3_19_1 Node0_3_19 Node0_3_20 76.99999999999984
R_0_3_19_2 Node0_3_19 Node0_4_19 76.99999999999984
R_0_3_19_3 Node0_3_19 Node1_3_19 3153.919999999994
I_0_3_20 GND Node0_3_20 4.082168000000008e-05A
R_0_3_20_1 Node0_3_20 Node0_3_21 76.99999999999997
R_0_3_20_2 Node0_3_20 Node0_4_20 76.99999999999984
R_0_3_20_3 Node0_3_20 Node1_3_20 3153.919999999994
I_0_3_21 GND Node0_3_21 4.0818489999999934e-05A
R_0_3_21_1 Node0_3_21 Node0_3_22 76.99999999999997
R_0_3_21_2 Node0_3_21 Node0_4_21 77.00000000000011
R_0_3_21_3 Node0_3_21 Node1_3_21 3153.920000000006
I_0_3_22 GND Node0_3_22 4.081639000000008e-05A
R_0_3_22_1 Node0_3_22 Node0_3_23 76.99999999999984
R_0_3_22_2 Node0_3_22 Node0_4_22 76.99999999999984
R_0_3_22_3 Node0_3_22 Node1_3_22 3153.919999999994
I_0_3_23 GND Node0_3_23 4.0815210000000084e-05A
R_0_3_23_1 Node0_3_23 Node0_3_24 76.99999999999984
R_0_3_23_2 Node0_3_23 Node0_4_23 76.99999999999984
R_0_3_23_3 Node0_3_23 Node1_3_23 3153.919999999994
I_0_3_24 GND Node0_3_24 4.081463000000008e-05A
R_0_3_24_1 Node0_3_24 Node0_3_25 76.99999999999984
R_0_3_24_2 Node0_3_24 Node0_4_24 76.99999999999984
R_0_3_24_3 Node0_3_24 Node1_3_24 3153.919999999994
I_0_3_25 GND Node0_3_25 4.081439000000008e-05A
R_0_3_25_1 Node0_3_25 Node0_3_26 76.99999999999984
R_0_3_25_2 Node0_3_25 Node0_4_25 76.99999999999984
R_0_3_25_3 Node0_3_25 Node1_3_25 3153.919999999994
I_0_3_26 GND Node0_3_26 4.081430000000008e-05A
R_0_3_26_1 Node0_3_26 Node0_3_27 76.99999999999984
R_0_3_26_2 Node0_3_26 Node0_4_26 76.99999999999984
R_0_3_26_3 Node0_3_26 Node1_3_26 3153.919999999994
I_0_3_27 GND Node0_3_27 4.081427000000008e-05A
R_0_3_27_1 Node0_3_27 Node0_3_28 76.99999999999984
R_0_3_27_2 Node0_3_27 Node0_4_27 76.99999999999984
R_0_3_27_3 Node0_3_27 Node1_3_27 3153.919999999994
I_0_3_28 GND Node0_3_28 4.081427000000008e-05A
R_0_3_28_1 Node0_3_28 Node0_3_29 76.99999999999997
R_0_3_28_2 Node0_3_28 Node0_4_28 76.99999999999984
R_0_3_28_3 Node0_3_28 Node1_3_28 3153.919999999994
I_0_3_29 GND Node0_3_29 4.081425999999993e-05A
R_0_3_29_1 Node0_3_29 Node0_3_30 76.99999999999997
R_0_3_29_2 Node0_3_29 Node0_4_29 77.00000000000011
R_0_3_29_3 Node0_3_29 Node1_3_29 3153.920000000006
I_0_3_30 GND Node0_3_30 4.081426000000008e-05A
R_0_3_30_1 Node0_3_30 Node0_3_31 76.99999999999984
R_0_3_30_2 Node0_3_30 Node0_4_30 76.99999999999984
R_0_3_30_3 Node0_3_30 Node1_3_30 3153.919999999994
I_0_3_31 GND Node0_3_31 4.081426000000008e-05A
R_0_3_31_2 Node0_3_31 Node0_4_31 76.99999999999984
R_0_3_31_3 Node0_3_31 Node1_3_31 3153.919999999994
I_0_4_0 GND Node0_4_0 4.0814260000000044e-05A
R_0_4_0_1 Node0_4_0 Node0_4_1 76.99999999999991
R_0_4_0_2 Node0_4_0 Node0_5_0 76.99999999999991
R_0_4_0_3 Node0_4_0 Node1_4_0 3153.9199999999973
I_0_4_1 GND Node0_4_1 4.0814260000000044e-05A
R_0_4_1_1 Node0_4_1 Node0_4_2 76.99999999999991
R_0_4_1_2 Node0_4_1 Node0_5_1 76.99999999999991
R_0_4_1_3 Node0_4_1 Node1_4_1 3153.9199999999973
I_0_4_2 GND Node0_4_2 4.0814260000000044e-05A
R_0_4_2_1 Node0_4_2 Node0_4_3 76.99999999999991
R_0_4_2_2 Node0_4_2 Node0_5_2 76.99999999999991
R_0_4_2_3 Node0_4_2 Node1_4_2 3153.9199999999973
I_0_4_3 GND Node0_4_3 4.0814270000000045e-05A
R_0_4_3_1 Node0_4_3 Node0_4_4 76.99999999999991
R_0_4_3_2 Node0_4_3 Node0_5_3 76.99999999999991
R_0_4_3_3 Node0_4_3 Node1_4_3 3153.9199999999973
I_0_4_4 GND Node0_4_4 4.0814270000000045e-05A
R_0_4_4_1 Node0_4_4 Node0_4_5 76.99999999999991
R_0_4_4_2 Node0_4_4 Node0_5_4 76.99999999999991
R_0_4_4_3 Node0_4_4 Node1_4_4 3153.9199999999973
I_0_4_5 GND Node0_4_5 4.081431000000004e-05A
R_0_4_5_1 Node0_4_5 Node0_4_6 76.99999999999991
R_0_4_5_2 Node0_4_5 Node0_5_5 76.99999999999991
R_0_4_5_3 Node0_4_5 Node1_4_5 3153.9199999999973
I_0_4_6 GND Node0_4_6 4.081443000000005e-05A
R_0_4_6_1 Node0_4_6 Node0_4_7 76.99999999999991
R_0_4_6_2 Node0_4_6 Node0_5_6 76.99999999999991
R_0_4_6_3 Node0_4_6 Node1_4_6 3153.9199999999973
I_0_4_7 GND Node0_4_7 4.081480000000005e-05A
R_0_4_7_1 Node0_4_7 Node0_4_8 76.99999999999989
R_0_4_7_2 Node0_4_7 Node0_5_7 76.99999999999991
R_0_4_7_3 Node0_4_7 Node1_4_7 3153.9199999999973
I_0_4_8 GND Node0_4_8 4.081582000000008e-05A
R_0_4_8_1 Node0_4_8 Node0_4_9 76.99999999999984
R_0_4_8_2 Node0_4_8 Node0_5_8 76.99999999999984
R_0_4_8_3 Node0_4_8 Node1_4_8 3153.919999999994
I_0_4_9 GND Node0_4_9 4.081823000000008e-05A
R_0_4_9_1 Node0_4_9 Node0_4_10 76.99999999999991
R_0_4_9_2 Node0_4_9 Node0_5_9 76.99999999999984
R_0_4_9_3 Node0_4_9 Node1_4_9 3153.919999999994
I_0_4_10 GND Node0_4_10 4.08232e-05A
R_0_4_10_1 Node0_4_10 Node0_4_11 76.99999999999991
R_0_4_10_2 Node0_4_10 Node0_5_10 77.0
R_0_4_10_3 Node0_4_10 Node1_4_10 3153.9200000000005
I_0_4_11 GND Node0_4_11 4.0832040000000075e-05A
R_0_4_11_1 Node0_4_11 Node0_4_12 76.99999999999984
R_0_4_11_2 Node0_4_11 Node0_5_11 76.99999999999984
R_0_4_11_3 Node0_4_11 Node1_4_11 3153.919999999994
I_0_4_12 GND Node0_4_12 4.084547000000008e-05A
R_0_4_12_1 Node0_4_12 Node0_4_13 76.99999999999984
R_0_4_12_2 Node0_4_12 Node0_5_12 76.99999999999984
R_0_4_12_3 Node0_4_12 Node1_4_12 3153.919999999994
I_0_4_13 GND Node0_4_13 4.086259000000008e-05A
R_0_4_13_1 Node0_4_13 Node0_4_14 76.99999999999991
R_0_4_13_2 Node0_4_13 Node0_5_13 76.99999999999984
R_0_4_13_3 Node0_4_13 Node1_4_13 3153.919999999994
I_0_4_14 GND Node0_4_14 4.088032e-05A
R_0_4_14_1 Node0_4_14 Node0_4_15 76.99999999999991
R_0_4_14_2 Node0_4_14 Node0_5_14 77.0
R_0_4_14_3 Node0_4_14 Node1_4_14 3153.9200000000005
I_0_4_15 GND Node0_4_15 4.089395000000008e-05A
R_0_4_15_1 Node0_4_15 Node0_4_16 76.99999999999984
R_0_4_15_2 Node0_4_15 Node0_5_15 76.99999999999984
R_0_4_15_3 Node0_4_15 Node1_4_15 3153.919999999994
I_0_4_16 GND Node0_4_16 4.0899090000000083e-05A
R_0_4_16_1 Node0_4_16 Node0_4_17 76.99999999999984
R_0_4_16_2 Node0_4_16 Node0_5_16 76.99999999999984
R_0_4_16_3 Node0_4_16 Node1_4_16 3153.919999999994
I_0_4_17 GND Node0_4_17 4.089395000000008e-05A
R_0_4_17_1 Node0_4_17 Node0_4_18 76.99999999999984
R_0_4_17_2 Node0_4_17 Node0_5_17 76.99999999999984
R_0_4_17_3 Node0_4_17 Node1_4_17 3153.919999999994
I_0_4_18 GND Node0_4_18 4.088032000000008e-05A
R_0_4_18_1 Node0_4_18 Node0_4_19 76.99999999999984
R_0_4_18_2 Node0_4_18 Node0_5_18 76.99999999999984
R_0_4_18_3 Node0_4_18 Node1_4_18 3153.919999999994
I_0_4_19 GND Node0_4_19 4.086259000000008e-05A
R_0_4_19_1 Node0_4_19 Node0_4_20 76.99999999999984
R_0_4_19_2 Node0_4_19 Node0_5_19 76.99999999999984
R_0_4_19_3 Node0_4_19 Node1_4_19 3153.919999999994
I_0_4_20 GND Node0_4_20 4.084547000000008e-05A
R_0_4_20_1 Node0_4_20 Node0_4_21 76.99999999999997
R_0_4_20_2 Node0_4_20 Node0_5_20 76.99999999999984
R_0_4_20_3 Node0_4_20 Node1_4_20 3153.919999999994
I_0_4_21 GND Node0_4_21 4.0832039999999926e-05A
R_0_4_21_1 Node0_4_21 Node0_4_22 76.99999999999997
R_0_4_21_2 Node0_4_21 Node0_5_21 77.00000000000011
R_0_4_21_3 Node0_4_21 Node1_4_21 3153.920000000006
I_0_4_22 GND Node0_4_22 4.082320000000008e-05A
R_0_4_22_1 Node0_4_22 Node0_4_23 76.99999999999984
R_0_4_22_2 Node0_4_22 Node0_5_22 76.99999999999984
R_0_4_22_3 Node0_4_22 Node1_4_22 3153.919999999994
I_0_4_23 GND Node0_4_23 4.081823000000008e-05A
R_0_4_23_1 Node0_4_23 Node0_4_24 76.99999999999984
R_0_4_23_2 Node0_4_23 Node0_5_23 76.99999999999984
R_0_4_23_3 Node0_4_23 Node1_4_23 3153.919999999994
I_0_4_24 GND Node0_4_24 4.081582000000008e-05A
R_0_4_24_1 Node0_4_24 Node0_4_25 76.99999999999984
R_0_4_24_2 Node0_4_24 Node0_5_24 76.99999999999984
R_0_4_24_3 Node0_4_24 Node1_4_24 3153.919999999994
I_0_4_25 GND Node0_4_25 4.081480000000008e-05A
R_0_4_25_1 Node0_4_25 Node0_4_26 76.99999999999984
R_0_4_25_2 Node0_4_25 Node0_5_25 76.99999999999984
R_0_4_25_3 Node0_4_25 Node1_4_25 3153.919999999994
I_0_4_26 GND Node0_4_26 4.0814430000000083e-05A
R_0_4_26_1 Node0_4_26 Node0_4_27 76.99999999999984
R_0_4_26_2 Node0_4_26 Node0_5_26 76.99999999999984
R_0_4_26_3 Node0_4_26 Node1_4_26 3153.919999999994
I_0_4_27 GND Node0_4_27 4.0814310000000075e-05A
R_0_4_27_1 Node0_4_27 Node0_4_28 76.99999999999984
R_0_4_27_2 Node0_4_27 Node0_5_27 76.99999999999984
R_0_4_27_3 Node0_4_27 Node1_4_27 3153.919999999994
I_0_4_28 GND Node0_4_28 4.081427000000008e-05A
R_0_4_28_1 Node0_4_28 Node0_4_29 76.99999999999997
R_0_4_28_2 Node0_4_28 Node0_5_28 76.99999999999984
R_0_4_28_3 Node0_4_28 Node1_4_28 3153.919999999994
I_0_4_29 GND Node0_4_29 4.081426999999993e-05A
R_0_4_29_1 Node0_4_29 Node0_4_30 76.99999999999997
R_0_4_29_2 Node0_4_29 Node0_5_29 77.00000000000011
R_0_4_29_3 Node0_4_29 Node1_4_29 3153.920000000006
I_0_4_30 GND Node0_4_30 4.081426000000008e-05A
R_0_4_30_1 Node0_4_30 Node0_4_31 76.99999999999984
R_0_4_30_2 Node0_4_30 Node0_5_30 76.99999999999984
R_0_4_30_3 Node0_4_30 Node1_4_30 3153.919999999994
I_0_4_31 GND Node0_4_31 4.081426000000008e-05A
R_0_4_31_2 Node0_4_31 Node0_5_31 76.99999999999984
R_0_4_31_3 Node0_4_31 Node1_4_31 3153.919999999994
I_0_5_0 GND Node0_5_0 4.0814260000000044e-05A
R_0_5_0_1 Node0_5_0 Node0_5_1 76.99999999999991
R_0_5_0_2 Node0_5_0 Node0_6_0 76.99999999999991
R_0_5_0_3 Node0_5_0 Node1_5_0 3153.9199999999973
I_0_5_1 GND Node0_5_1 4.0814260000000044e-05A
R_0_5_1_1 Node0_5_1 Node0_5_2 76.99999999999991
R_0_5_1_2 Node0_5_1 Node0_6_1 76.99999999999991
R_0_5_1_3 Node0_5_1 Node1_5_1 3153.9199999999973
I_0_5_2 GND Node0_5_2 4.0814260000000044e-05A
R_0_5_2_1 Node0_5_2 Node0_5_3 76.99999999999991
R_0_5_2_2 Node0_5_2 Node0_6_2 76.99999999999991
R_0_5_2_3 Node0_5_2 Node1_5_2 3153.9199999999973
I_0_5_3 GND Node0_5_3 4.0814270000000045e-05A
R_0_5_3_1 Node0_5_3 Node0_5_4 76.99999999999991
R_0_5_3_2 Node0_5_3 Node0_6_3 76.99999999999991
R_0_5_3_3 Node0_5_3 Node1_5_3 3153.9199999999973
I_0_5_4 GND Node0_5_4 4.081430000000005e-05A
R_0_5_4_1 Node0_5_4 Node0_5_5 76.99999999999991
R_0_5_4_2 Node0_5_4 Node0_6_4 76.99999999999991
R_0_5_4_3 Node0_5_4 Node1_5_4 3153.9199999999973
I_0_5_5 GND Node0_5_5 4.081443000000005e-05A
R_0_5_5_1 Node0_5_5 Node0_5_6 76.99999999999991
R_0_5_5_2 Node0_5_5 Node0_6_5 76.99999999999991
R_0_5_5_3 Node0_5_5 Node1_5_5 3153.9199999999973
I_0_5_6 GND Node0_5_6 4.0814870000000047e-05A
R_0_5_6_1 Node0_5_6 Node0_5_7 76.99999999999991
R_0_5_6_2 Node0_5_6 Node0_6_6 76.99999999999991
R_0_5_6_3 Node0_5_6 Node1_5_6 3153.9199999999973
I_0_5_7 GND Node0_5_7 4.081626000000004e-05A
R_0_5_7_1 Node0_5_7 Node0_5_8 76.99999999999989
R_0_5_7_2 Node0_5_7 Node0_6_7 76.99999999999991
R_0_5_7_3 Node0_5_7 Node1_5_7 3153.9199999999973
I_0_5_8 GND Node0_5_8 4.082004000000008e-05A
R_0_5_8_1 Node0_5_8 Node0_5_9 76.99999999999984
R_0_5_8_2 Node0_5_8 Node0_6_8 76.99999999999984
R_0_5_8_3 Node0_5_8 Node1_5_8 3153.919999999994
I_0_5_9 GND Node0_5_9 4.082900000000008e-05A
R_0_5_9_1 Node0_5_9 Node0_5_10 76.99999999999991
R_0_5_9_2 Node0_5_9 Node0_6_9 76.99999999999984
R_0_5_9_3 Node0_5_9 Node1_5_9 3153.919999999994
I_0_5_10 GND Node0_5_10 4.084748e-05A
R_0_5_10_1 Node0_5_10 Node0_5_11 76.99999999999991
R_0_5_10_2 Node0_5_10 Node0_6_10 77.0
R_0_5_10_3 Node0_5_10 Node1_5_10 3153.9200000000005
I_0_5_11 GND Node0_5_11 4.088032000000008e-05A
R_0_5_11_1 Node0_5_11 Node0_5_12 76.99999999999984
R_0_5_11_2 Node0_5_11 Node0_6_11 76.99999999999984
R_0_5_11_3 Node0_5_11 Node1_5_11 3153.919999999994
I_0_5_12 GND Node0_5_12 4.0930200000000085e-05A
R_0_5_12_1 Node0_5_12 Node0_5_13 76.99999999999984
R_0_5_12_2 Node0_5_12 Node0_6_12 76.99999999999984
R_0_5_12_3 Node0_5_12 Node1_5_12 3153.919999999994
I_0_5_13 GND Node0_5_13 4.0993840000000085e-05A
R_0_5_13_1 Node0_5_13 Node0_5_14 76.99999999999991
R_0_5_13_2 Node0_5_13 Node0_6_13 76.99999999999984
R_0_5_13_3 Node0_5_13 Node1_5_13 3153.919999999994
I_0_5_14 GND Node0_5_14 4.105971e-05A
R_0_5_14_1 Node0_5_14 Node0_5_15 76.99999999999991
R_0_5_14_2 Node0_5_14 Node0_6_14 77.0
R_0_5_14_3 Node0_5_14 Node1_5_14 3153.9200000000005
I_0_5_15 GND Node0_5_15 4.111033000000008e-05A
R_0_5_15_1 Node0_5_15 Node0_5_16 76.99999999999984
R_0_5_15_2 Node0_5_15 Node0_6_15 76.99999999999984
R_0_5_15_3 Node0_5_15 Node1_5_15 3153.919999999994
I_0_5_16 GND Node0_5_16 4.112942000000008e-05A
R_0_5_16_1 Node0_5_16 Node0_5_17 76.99999999999984
R_0_5_16_2 Node0_5_16 Node0_6_16 76.99999999999984
R_0_5_16_3 Node0_5_16 Node1_5_16 3153.919999999994
I_0_5_17 GND Node0_5_17 4.111033000000008e-05A
R_0_5_17_1 Node0_5_17 Node0_5_18 76.99999999999984
R_0_5_17_2 Node0_5_17 Node0_6_17 76.99999999999984
R_0_5_17_3 Node0_5_17 Node1_5_17 3153.919999999994
I_0_5_18 GND Node0_5_18 4.1059710000000085e-05A
R_0_5_18_1 Node0_5_18 Node0_5_19 76.99999999999984
R_0_5_18_2 Node0_5_18 Node0_6_18 76.99999999999984
R_0_5_18_3 Node0_5_18 Node1_5_18 3153.919999999994
I_0_5_19 GND Node0_5_19 4.0993840000000085e-05A
R_0_5_19_1 Node0_5_19 Node0_5_20 76.99999999999984
R_0_5_19_2 Node0_5_19 Node0_6_19 76.99999999999984
R_0_5_19_3 Node0_5_19 Node1_5_19 3153.919999999994
I_0_5_20 GND Node0_5_20 4.0930200000000085e-05A
R_0_5_20_1 Node0_5_20 Node0_5_21 76.99999999999997
R_0_5_20_2 Node0_5_20 Node0_6_20 76.99999999999984
R_0_5_20_3 Node0_5_20 Node1_5_20 3153.919999999994
I_0_5_21 GND Node0_5_21 4.088031999999993e-05A
R_0_5_21_1 Node0_5_21 Node0_5_22 76.99999999999997
R_0_5_21_2 Node0_5_21 Node0_6_21 77.00000000000011
R_0_5_21_3 Node0_5_21 Node1_5_21 3153.920000000006
I_0_5_22 GND Node0_5_22 4.084748000000008e-05A
R_0_5_22_1 Node0_5_22 Node0_5_23 76.99999999999984
R_0_5_22_2 Node0_5_22 Node0_6_22 76.99999999999984
R_0_5_22_3 Node0_5_22 Node1_5_22 3153.919999999994
I_0_5_23 GND Node0_5_23 4.082900000000008e-05A
R_0_5_23_1 Node0_5_23 Node0_5_24 76.99999999999984
R_0_5_23_2 Node0_5_23 Node0_6_23 76.99999999999984
R_0_5_23_3 Node0_5_23 Node1_5_23 3153.919999999994
I_0_5_24 GND Node0_5_24 4.082004000000008e-05A
R_0_5_24_1 Node0_5_24 Node0_5_25 76.99999999999984
R_0_5_24_2 Node0_5_24 Node0_6_24 76.99999999999984
R_0_5_24_3 Node0_5_24 Node1_5_24 3153.919999999994
I_0_5_25 GND Node0_5_25 4.0816260000000076e-05A
R_0_5_25_1 Node0_5_25 Node0_5_26 76.99999999999984
R_0_5_25_2 Node0_5_25 Node0_6_25 76.99999999999984
R_0_5_25_3 Node0_5_25 Node1_5_25 3153.919999999994
I_0_5_26 GND Node0_5_26 4.081487000000008e-05A
R_0_5_26_1 Node0_5_26 Node0_5_27 76.99999999999984
R_0_5_26_2 Node0_5_26 Node0_6_26 76.99999999999984
R_0_5_26_3 Node0_5_26 Node1_5_26 3153.919999999994
I_0_5_27 GND Node0_5_27 4.0814430000000083e-05A
R_0_5_27_1 Node0_5_27 Node0_5_28 76.99999999999984
R_0_5_27_2 Node0_5_27 Node0_6_27 76.99999999999984
R_0_5_27_3 Node0_5_27 Node1_5_27 3153.919999999994
I_0_5_28 GND Node0_5_28 4.081430000000008e-05A
R_0_5_28_1 Node0_5_28 Node0_5_29 76.99999999999997
R_0_5_28_2 Node0_5_28 Node0_6_28 76.99999999999984
R_0_5_28_3 Node0_5_28 Node1_5_28 3153.919999999994
I_0_5_29 GND Node0_5_29 4.081426999999993e-05A
R_0_5_29_1 Node0_5_29 Node0_5_30 76.99999999999997
R_0_5_29_2 Node0_5_29 Node0_6_29 77.00000000000011
R_0_5_29_3 Node0_5_29 Node1_5_29 3153.920000000006
I_0_5_30 GND Node0_5_30 4.081426000000008e-05A
R_0_5_30_1 Node0_5_30 Node0_5_31 76.99999999999984
R_0_5_30_2 Node0_5_30 Node0_6_30 76.99999999999984
R_0_5_30_3 Node0_5_30 Node1_5_30 3153.919999999994
I_0_5_31 GND Node0_5_31 4.081426000000008e-05A
R_0_5_31_2 Node0_5_31 Node0_6_31 76.99999999999984
R_0_5_31_3 Node0_5_31 Node1_5_31 3153.919999999994
I_0_6_0 GND Node0_6_0 4.0814260000000044e-05A
R_0_6_0_1 Node0_6_0 Node0_6_1 76.99999999999991
R_0_6_0_2 Node0_6_0 Node0_7_0 76.99999999999991
R_0_6_0_3 Node0_6_0 Node1_6_0 3153.9199999999973
I_0_6_1 GND Node0_6_1 4.0814260000000044e-05A
R_0_6_1_1 Node0_6_1 Node0_6_2 76.99999999999991
R_0_6_1_2 Node0_6_1 Node0_7_1 76.99999999999991
R_0_6_1_3 Node0_6_1 Node1_6_1 3153.9199999999973
I_0_6_2 GND Node0_6_2 4.0814270000000045e-05A
R_0_6_2_1 Node0_6_2 Node0_6_3 76.99999999999991
R_0_6_2_2 Node0_6_2 Node0_7_2 76.99999999999991
R_0_6_2_3 Node0_6_2 Node1_6_2 3153.9199999999973
I_0_6_3 GND Node0_6_3 4.0814290000000047e-05A
R_0_6_3_1 Node0_6_3 Node0_6_4 76.99999999999991
R_0_6_3_2 Node0_6_3 Node0_7_3 76.99999999999991
R_0_6_3_3 Node0_6_3 Node1_6_3 3153.9199999999973
I_0_6_4 GND Node0_6_4 4.081439000000005e-05A
R_0_6_4_1 Node0_6_4 Node0_6_5 76.99999999999991
R_0_6_4_2 Node0_6_4 Node0_7_4 76.99999999999991
R_0_6_4_3 Node0_6_4 Node1_6_4 3153.9199999999973
I_0_6_5 GND Node0_6_5 4.081480000000005e-05A
R_0_6_5_1 Node0_6_5 Node0_6_6 76.99999999999991
R_0_6_5_2 Node0_6_5 Node0_7_5 76.99999999999991
R_0_6_5_3 Node0_6_5 Node1_6_5 3153.9199999999973
I_0_6_6 GND Node0_6_6 4.081626000000004e-05A
R_0_6_6_1 Node0_6_6 Node0_6_7 76.99999999999991
R_0_6_6_2 Node0_6_6 Node0_7_6 76.99999999999991
R_0_6_6_3 Node0_6_6 Node1_6_6 3153.9199999999973
I_0_6_7 GND Node0_6_7 4.082080000000005e-05A
R_0_6_7_1 Node0_6_7 Node0_6_8 76.99999999999989
R_0_6_7_2 Node0_6_7 Node0_7_7 76.99999999999991
R_0_6_7_3 Node0_6_7 Node1_6_7 3153.9199999999973
I_0_6_8 GND Node0_6_8 4.083319000000008e-05A
R_0_6_8_1 Node0_6_8 Node0_6_9 76.99999999999984
R_0_6_8_2 Node0_6_8 Node0_7_8 76.99999999999984
R_0_6_8_3 Node0_6_8 Node1_6_8 3153.919999999994
I_0_6_9 GND Node0_6_9 4.086259000000008e-05A
R_0_6_9_1 Node0_6_9 Node0_6_10 76.99999999999991
R_0_6_9_2 Node0_6_9 Node0_7_9 76.99999999999984
R_0_6_9_3 Node0_6_9 Node1_6_9 3153.919999999994
I_0_6_10 GND Node0_6_10 4.092318e-05A
R_0_6_10_1 Node0_6_10 Node0_6_11 76.99999999999991
R_0_6_10_2 Node0_6_10 Node0_7_10 77.0
R_0_6_10_3 Node0_6_10 Node1_6_10 3153.9200000000005
I_0_6_11 GND Node0_6_11 4.103087000000008e-05A
R_0_6_11_1 Node0_6_11 Node0_6_12 76.99999999999984
R_0_6_11_2 Node0_6_11 Node0_7_11 76.99999999999984
R_0_6_11_3 Node0_6_11 Node1_6_11 3153.919999999994
I_0_6_12 GND Node0_6_12 4.119442000000008e-05A
R_0_6_12_1 Node0_6_12 Node0_6_13 76.99999999999984
R_0_6_12_2 Node0_6_12 Node0_7_12 76.99999999999984
R_0_6_12_3 Node0_6_12 Node1_6_12 3153.919999999994
I_0_6_13 GND Node0_6_13 4.140306000000008e-05A
R_0_6_13_1 Node0_6_13 Node0_6_14 76.99999999999991
R_0_6_13_2 Node0_6_13 Node0_7_13 76.99999999999984
R_0_6_13_3 Node0_6_13 Node1_6_13 3153.919999999994
I_0_6_14 GND Node0_6_14 4.161905e-05A
R_0_6_14_1 Node0_6_14 Node0_6_15 76.99999999999991
R_0_6_14_2 Node0_6_14 Node0_7_14 77.0
R_0_6_14_3 Node0_6_14 Node1_6_14 3153.9200000000005
I_0_6_15 GND Node0_6_15 4.1785030000000084e-05A
R_0_6_15_1 Node0_6_15 Node0_6_16 76.99999999999984
R_0_6_15_2 Node0_6_15 Node0_7_15 76.99999999999984
R_0_6_15_3 Node0_6_15 Node1_6_15 3153.919999999994
I_0_6_16 GND Node0_6_16 4.184763000000008e-05A
R_0_6_16_1 Node0_6_16 Node0_6_17 76.99999999999984
R_0_6_16_2 Node0_6_16 Node0_7_16 76.99999999999984
R_0_6_16_3 Node0_6_16 Node1_6_16 3153.919999999994
I_0_6_17 GND Node0_6_17 4.1785030000000084e-05A
R_0_6_17_1 Node0_6_17 Node0_6_18 76.99999999999984
R_0_6_17_2 Node0_6_17 Node0_7_17 76.99999999999984
R_0_6_17_3 Node0_6_17 Node1_6_17 3153.919999999994
I_0_6_18 GND Node0_6_18 4.161905000000008e-05A
R_0_6_18_1 Node0_6_18 Node0_6_19 76.99999999999984
R_0_6_18_2 Node0_6_18 Node0_7_18 76.99999999999984
R_0_6_18_3 Node0_6_18 Node1_6_18 3153.919999999994
I_0_6_19 GND Node0_6_19 4.140306000000008e-05A
R_0_6_19_1 Node0_6_19 Node0_6_20 76.99999999999984
R_0_6_19_2 Node0_6_19 Node0_7_19 76.99999999999984
R_0_6_19_3 Node0_6_19 Node1_6_19 3153.919999999994
I_0_6_20 GND Node0_6_20 4.119442000000008e-05A
R_0_6_20_1 Node0_6_20 Node0_6_21 76.99999999999997
R_0_6_20_2 Node0_6_20 Node0_7_20 76.99999999999984
R_0_6_20_3 Node0_6_20 Node1_6_20 3153.919999999994
I_0_6_21 GND Node0_6_21 4.103086999999993e-05A
R_0_6_21_1 Node0_6_21 Node0_6_22 76.99999999999997
R_0_6_21_2 Node0_6_21 Node0_7_21 77.00000000000011
R_0_6_21_3 Node0_6_21 Node1_6_21 3153.920000000006
I_0_6_22 GND Node0_6_22 4.092318000000008e-05A
R_0_6_22_1 Node0_6_22 Node0_6_23 76.99999999999984
R_0_6_22_2 Node0_6_22 Node0_7_22 76.99999999999984
R_0_6_22_3 Node0_6_22 Node1_6_22 3153.919999999994
I_0_6_23 GND Node0_6_23 4.086259000000008e-05A
R_0_6_23_1 Node0_6_23 Node0_6_24 76.99999999999984
R_0_6_23_2 Node0_6_23 Node0_7_23 76.99999999999984
R_0_6_23_3 Node0_6_23 Node1_6_23 3153.919999999994
I_0_6_24 GND Node0_6_24 4.083319000000008e-05A
R_0_6_24_1 Node0_6_24 Node0_6_25 76.99999999999984
R_0_6_24_2 Node0_6_24 Node0_7_24 76.99999999999984
R_0_6_24_3 Node0_6_24 Node1_6_24 3153.919999999994
I_0_6_25 GND Node0_6_25 4.082080000000008e-05A
R_0_6_25_1 Node0_6_25 Node0_6_26 76.99999999999984
R_0_6_25_2 Node0_6_25 Node0_7_25 76.99999999999984
R_0_6_25_3 Node0_6_25 Node1_6_25 3153.919999999994
I_0_6_26 GND Node0_6_26 4.0816260000000076e-05A
R_0_6_26_1 Node0_6_26 Node0_6_27 76.99999999999984
R_0_6_26_2 Node0_6_26 Node0_7_26 76.99999999999984
R_0_6_26_3 Node0_6_26 Node1_6_26 3153.919999999994
I_0_6_27 GND Node0_6_27 4.081480000000008e-05A
R_0_6_27_1 Node0_6_27 Node0_6_28 76.99999999999984
R_0_6_27_2 Node0_6_27 Node0_7_27 76.99999999999984
R_0_6_27_3 Node0_6_27 Node1_6_27 3153.919999999994
I_0_6_28 GND Node0_6_28 4.081439000000008e-05A
R_0_6_28_1 Node0_6_28 Node0_6_29 76.99999999999997
R_0_6_28_2 Node0_6_28 Node0_7_28 76.99999999999984
R_0_6_28_3 Node0_6_28 Node1_6_28 3153.919999999994
I_0_6_29 GND Node0_6_29 4.081428999999993e-05A
R_0_6_29_1 Node0_6_29 Node0_6_30 76.99999999999997
R_0_6_29_2 Node0_6_29 Node0_7_29 77.00000000000011
R_0_6_29_3 Node0_6_29 Node1_6_29 3153.920000000006
I_0_6_30 GND Node0_6_30 4.081427000000008e-05A
R_0_6_30_1 Node0_6_30 Node0_6_31 76.99999999999984
R_0_6_30_2 Node0_6_30 Node0_7_30 76.99999999999984
R_0_6_30_3 Node0_6_30 Node1_6_30 3153.919999999994
I_0_6_31 GND Node0_6_31 4.081426000000008e-05A
R_0_6_31_2 Node0_6_31 Node0_7_31 76.99999999999984
R_0_6_31_3 Node0_6_31 Node1_6_31 3153.919999999994
I_0_7_0 GND Node0_7_0 4.0814260000000044e-05A
R_0_7_0_1 Node0_7_0 Node0_7_1 76.99999999999991
R_0_7_0_2 Node0_7_0 Node0_8_0 76.99999999999991
R_0_7_0_3 Node0_7_0 Node1_7_0 3153.9199999999973
I_0_7_1 GND Node0_7_1 4.0814270000000045e-05A
R_0_7_1_1 Node0_7_1 Node0_7_2 76.99999999999991
R_0_7_1_2 Node0_7_1 Node0_8_1 76.99999999999991
R_0_7_1_3 Node0_7_1 Node1_7_1 3153.9199999999973
I_0_7_2 GND Node0_7_2 4.0814280000000046e-05A
R_0_7_2_1 Node0_7_2 Node0_7_3 76.99999999999991
R_0_7_2_2 Node0_7_2 Node0_8_2 76.99999999999991
R_0_7_2_3 Node0_7_2 Node1_7_2 3153.9199999999973
I_0_7_3 GND Node0_7_3 4.081434000000005e-05A
R_0_7_3_1 Node0_7_3 Node0_7_4 76.99999999999991
R_0_7_3_2 Node0_7_3 Node0_8_3 76.99999999999991
R_0_7_3_3 Node0_7_3 Node1_7_3 3153.9199999999973
I_0_7_4 GND Node0_7_4 4.081463000000004e-05A
R_0_7_4_1 Node0_7_4 Node0_7_5 76.99999999999991
R_0_7_4_2 Node0_7_4 Node0_8_4 76.99999999999991
R_0_7_4_3 Node0_7_4 Node1_7_4 3153.9199999999973
I_0_7_5 GND Node0_7_5 4.0815820000000045e-05A
R_0_7_5_1 Node0_7_5 Node0_7_6 76.99999999999991
R_0_7_5_2 Node0_7_5 Node0_8_5 76.99999999999991
R_0_7_5_3 Node0_7_5 Node1_7_5 3153.9199999999973
I_0_7_6 GND Node0_7_6 4.082004000000005e-05A
R_0_7_6_1 Node0_7_6 Node0_7_7 76.99999999999991
R_0_7_6_2 Node0_7_6 Node0_8_6 76.99999999999991
R_0_7_6_3 Node0_7_6 Node1_7_6 3153.9199999999973
I_0_7_7 GND Node0_7_7 4.083319000000005e-05A
R_0_7_7_1 Node0_7_7 Node0_7_8 76.99999999999989
R_0_7_7_2 Node0_7_7 Node0_8_7 76.99999999999991
R_0_7_7_3 Node0_7_7 Node1_7_7 3153.9199999999973
I_0_7_8 GND Node0_7_8 4.086903000000008e-05A
R_0_7_8_1 Node0_7_8 Node0_7_9 76.99999999999984
R_0_7_8_2 Node0_7_8 Node0_8_8 76.99999999999984
R_0_7_8_3 Node0_7_8 Node1_7_8 3153.919999999994
I_0_7_9 GND Node0_7_9 4.0954110000000083e-05A
R_0_7_9_1 Node0_7_9 Node0_7_10 76.99999999999991
R_0_7_9_2 Node0_7_9 Node0_8_9 76.99999999999984
R_0_7_9_3 Node0_7_9 Node1_7_9 3153.919999999994
I_0_7_10 GND Node0_7_10 4.112942e-05A
R_0_7_10_1 Node0_7_10 Node0_7_11 76.99999999999991
R_0_7_10_2 Node0_7_10 Node0_8_10 77.0
R_0_7_10_3 Node0_7_10 Node1_7_10 3153.9200000000005
I_0_7_11 GND Node0_7_11 4.144103000000008e-05A
R_0_7_11_1 Node0_7_11 Node0_7_12 76.99999999999984
R_0_7_11_2 Node0_7_11 Node0_8_11 76.99999999999984
R_0_7_11_3 Node0_7_11 Node1_7_11 3153.919999999994
I_0_7_12 GND Node0_7_12 4.191428000000008e-05A
R_0_7_12_1 Node0_7_12 Node0_7_13 76.99999999999984
R_0_7_12_2 Node0_7_12 Node0_8_12 76.99999999999984
R_0_7_12_3 Node0_7_12 Node1_7_12 3153.919999999994
I_0_7_13 GND Node0_7_13 4.251800000000009e-05A
R_0_7_13_1 Node0_7_13 Node0_7_14 76.99999999999991
R_0_7_13_2 Node0_7_13 Node0_8_13 76.99999999999984
R_0_7_13_3 Node0_7_13 Node1_7_13 3153.919999999994
I_0_7_14 GND Node0_7_14 4.3143e-05A
R_0_7_14_1 Node0_7_14 Node0_7_15 76.99999999999991
R_0_7_14_2 Node0_7_14 Node0_8_14 77.0
R_0_7_14_3 Node0_7_14 Node1_7_14 3153.9200000000005
I_0_7_15 GND Node0_7_15 4.3623260000000085e-05A
R_0_7_15_1 Node0_7_15 Node0_7_16 76.99999999999984
R_0_7_15_2 Node0_7_15 Node0_8_15 76.99999999999984
R_0_7_15_3 Node0_7_15 Node1_7_15 3153.919999999994
I_0_7_16 GND Node0_7_16 4.3804420000000086e-05A
R_0_7_16_1 Node0_7_16 Node0_7_17 76.99999999999984
R_0_7_16_2 Node0_7_16 Node0_8_16 76.99999999999984
R_0_7_16_3 Node0_7_16 Node1_7_16 3153.919999999994
I_0_7_17 GND Node0_7_17 4.3623260000000085e-05A
R_0_7_17_1 Node0_7_17 Node0_7_18 76.99999999999984
R_0_7_17_2 Node0_7_17 Node0_8_17 76.99999999999984
R_0_7_17_3 Node0_7_17 Node1_7_17 3153.919999999994
I_0_7_18 GND Node0_7_18 4.3143000000000085e-05A
R_0_7_18_1 Node0_7_18 Node0_7_19 76.99999999999984
R_0_7_18_2 Node0_7_18 Node0_8_18 76.99999999999984
R_0_7_18_3 Node0_7_18 Node1_7_18 3153.919999999994
I_0_7_19 GND Node0_7_19 4.251800000000009e-05A
R_0_7_19_1 Node0_7_19 Node0_7_20 76.99999999999984
R_0_7_19_2 Node0_7_19 Node0_8_19 76.99999999999984
R_0_7_19_3 Node0_7_19 Node1_7_19 3153.919999999994
I_0_7_20 GND Node0_7_20 4.191428000000008e-05A
R_0_7_20_1 Node0_7_20 Node0_7_21 76.99999999999997
R_0_7_20_2 Node0_7_20 Node0_8_20 76.99999999999984
R_0_7_20_3 Node0_7_20 Node1_7_20 3153.919999999994
I_0_7_21 GND Node0_7_21 4.144102999999993e-05A
R_0_7_21_1 Node0_7_21 Node0_7_22 76.99999999999997
R_0_7_21_2 Node0_7_21 Node0_8_21 77.00000000000011
R_0_7_21_3 Node0_7_21 Node1_7_21 3153.920000000006
I_0_7_22 GND Node0_7_22 4.112942000000008e-05A
R_0_7_22_1 Node0_7_22 Node0_7_23 76.99999999999984
R_0_7_22_2 Node0_7_22 Node0_8_22 76.99999999999984
R_0_7_22_3 Node0_7_22 Node1_7_22 3153.919999999994
I_0_7_23 GND Node0_7_23 4.0954110000000083e-05A
R_0_7_23_1 Node0_7_23 Node0_7_24 76.99999999999984
R_0_7_23_2 Node0_7_23 Node0_8_23 76.99999999999984
R_0_7_23_3 Node0_7_23 Node1_7_23 3153.919999999994
I_0_7_24 GND Node0_7_24 4.086903000000008e-05A
R_0_7_24_1 Node0_7_24 Node0_7_25 76.99999999999984
R_0_7_24_2 Node0_7_24 Node0_8_24 76.99999999999984
R_0_7_24_3 Node0_7_24 Node1_7_24 3153.919999999994
I_0_7_25 GND Node0_7_25 4.083319000000008e-05A
R_0_7_25_1 Node0_7_25 Node0_7_26 76.99999999999984
R_0_7_25_2 Node0_7_25 Node0_8_25 76.99999999999984
R_0_7_25_3 Node0_7_25 Node1_7_25 3153.919999999994
I_0_7_26 GND Node0_7_26 4.082004000000008e-05A
R_0_7_26_1 Node0_7_26 Node0_7_27 76.99999999999984
R_0_7_26_2 Node0_7_26 Node0_8_26 76.99999999999984
R_0_7_26_3 Node0_7_26 Node1_7_26 3153.919999999994
I_0_7_27 GND Node0_7_27 4.081582000000008e-05A
R_0_7_27_1 Node0_7_27 Node0_7_28 76.99999999999984
R_0_7_27_2 Node0_7_27 Node0_8_27 76.99999999999984
R_0_7_27_3 Node0_7_27 Node1_7_27 3153.919999999994
I_0_7_28 GND Node0_7_28 4.081463000000008e-05A
R_0_7_28_1 Node0_7_28 Node0_7_29 76.99999999999997
R_0_7_28_2 Node0_7_28 Node0_8_28 76.99999999999984
R_0_7_28_3 Node0_7_28 Node1_7_28 3153.919999999994
I_0_7_29 GND Node0_7_29 4.0814339999999935e-05A
R_0_7_29_1 Node0_7_29 Node0_7_30 76.99999999999997
R_0_7_29_2 Node0_7_29 Node0_8_29 77.00000000000011
R_0_7_29_3 Node0_7_29 Node1_7_29 3153.920000000006
I_0_7_30 GND Node0_7_30 4.081428000000008e-05A
R_0_7_30_1 Node0_7_30 Node0_7_31 76.99999999999984
R_0_7_30_2 Node0_7_30 Node0_8_30 76.99999999999984
R_0_7_30_3 Node0_7_30 Node1_7_30 3153.919999999994
I_0_7_31 GND Node0_7_31 4.081427000000008e-05A
R_0_7_31_2 Node0_7_31 Node0_8_31 76.99999999999984
R_0_7_31_3 Node0_7_31 Node1_7_31 3153.919999999994
I_0_8_0 GND Node0_8_0 4.0814260000000044e-05A
R_0_8_0_1 Node0_8_0 Node0_8_1 76.99999999999991
R_0_8_0_2 Node0_8_0 Node0_9_0 76.99999999999991
R_0_8_0_3 Node0_8_0 Node1_8_0 3153.9199999999973
I_0_8_1 GND Node0_8_1 4.0814270000000045e-05A
R_0_8_1_1 Node0_8_1 Node0_8_2 76.99999999999991
R_0_8_1_2 Node0_8_1 Node0_9_1 76.99999999999991
R_0_8_1_3 Node0_8_1 Node1_8_1 3153.9199999999973
I_0_8_2 GND Node0_8_2 4.081430000000005e-05A
R_0_8_2_1 Node0_8_2 Node0_8_3 76.99999999999991
R_0_8_2_2 Node0_8_2 Node0_9_2 76.99999999999991
R_0_8_2_3 Node0_8_2 Node1_8_2 3153.9199999999973
I_0_8_3 GND Node0_8_3 4.0814460000000045e-05A
R_0_8_3_1 Node0_8_3 Node0_8_4 76.99999999999991
R_0_8_3_2 Node0_8_3 Node0_9_3 76.99999999999991
R_0_8_3_3 Node0_8_3 Node1_8_3 3153.9199999999973
I_0_8_4 GND Node0_8_4 4.081521000000005e-05A
R_0_8_4_1 Node0_8_4 Node0_8_5 76.99999999999991
R_0_8_4_2 Node0_8_4 Node0_9_4 76.99999999999991
R_0_8_4_3 Node0_8_4 Node1_8_4 3153.9199999999973
I_0_8_5 GND Node0_8_5 4.0818230000000044e-05A
R_0_8_5_1 Node0_8_5 Node0_8_6 76.99999999999991
R_0_8_5_2 Node0_8_5 Node0_9_5 76.99999999999991
R_0_8_5_3 Node0_8_5 Node1_8_5 3153.9199999999973
I_0_8_6 GND Node0_8_6 4.0829000000000046e-05A
R_0_8_6_1 Node0_8_6 Node0_8_7 76.99999999999991
R_0_8_6_2 Node0_8_6 Node0_9_6 76.99999999999991
R_0_8_6_3 Node0_8_6 Node1_8_6 3153.9199999999973
I_0_8_7 GND Node0_8_7 4.0862590000000044e-05A
R_0_8_7_1 Node0_8_7 Node0_8_8 76.99999999999989
R_0_8_7_2 Node0_8_7 Node0_9_7 76.99999999999991
R_0_8_7_3 Node0_8_7 Node1_8_7 3153.9199999999973
I_0_8_8 GND Node0_8_8 4.0954110000000083e-05A
R_0_8_8_1 Node0_8_8 Node0_8_9 76.99999999999984
R_0_8_8_2 Node0_8_8 Node0_9_8 76.99999999999984
R_0_8_8_3 Node0_8_8 Node1_8_8 3153.919999999994
I_0_8_9 GND Node0_8_9 4.1171390000000084e-05A
R_0_8_9_1 Node0_8_9 Node0_8_10 76.99999999999991
R_0_8_9_2 Node0_8_9 Node0_9_9 76.99999999999984
R_0_8_9_3 Node0_8_9 Node1_8_9 3153.919999999994
I_0_8_10 GND Node0_8_10 4.161905e-05A
R_0_8_10_1 Node0_8_10 Node0_8_11 76.99999999999991
R_0_8_10_2 Node0_8_10 Node0_9_10 77.0
R_0_8_10_3 Node0_8_10 Node1_8_10 3153.9200000000005
I_0_8_11 GND Node0_8_11 4.2414780000000086e-05A
R_0_8_11_1 Node0_8_11 Node0_8_12 76.99999999999984
R_0_8_11_2 Node0_8_11 Node0_9_11 76.99999999999984
R_0_8_11_3 Node0_8_11 Node1_8_11 3153.919999999994
I_0_8_12 GND Node0_8_12 4.3623260000000085e-05A
R_0_8_12_1 Node0_8_12 Node0_8_13 76.99999999999984
R_0_8_12_2 Node0_8_12 Node0_9_12 76.99999999999984
R_0_8_12_3 Node0_8_12 Node1_8_12 3153.919999999994
I_0_8_13 GND Node0_8_13 4.516492000000009e-05A
R_0_8_13_1 Node0_8_13 Node0_8_14 76.99999999999991
R_0_8_13_2 Node0_8_13 Node0_9_13 76.99999999999984
R_0_8_13_3 Node0_8_13 Node1_8_13 3153.919999999994
I_0_8_14 GND Node0_8_14 4.67609e-05A
R_0_8_14_1 Node0_8_14 Node0_8_15 76.99999999999991
R_0_8_14_2 Node0_8_14 Node0_9_14 77.0
R_0_8_14_3 Node0_8_14 Node1_8_14 3153.9200000000005
I_0_8_15 GND Node0_8_15 4.7987280000000094e-05A
R_0_8_15_1 Node0_8_15 Node0_8_16 76.99999999999984
R_0_8_15_2 Node0_8_15 Node0_9_15 76.99999999999984
R_0_8_15_3 Node0_8_15 Node1_8_15 3153.919999999994
I_0_8_16 GND Node0_8_16 4.844990000000009e-05A
R_0_8_16_1 Node0_8_16 Node0_8_17 76.99999999999984
R_0_8_16_2 Node0_8_16 Node0_9_16 76.99999999999984
R_0_8_16_3 Node0_8_16 Node1_8_16 3153.919999999994
I_0_8_17 GND Node0_8_17 4.7987280000000094e-05A
R_0_8_17_1 Node0_8_17 Node0_8_18 76.99999999999984
R_0_8_17_2 Node0_8_17 Node0_9_17 76.99999999999984
R_0_8_17_3 Node0_8_17 Node1_8_17 3153.919999999994
I_0_8_18 GND Node0_8_18 4.6760900000000096e-05A
R_0_8_18_1 Node0_8_18 Node0_8_19 76.99999999999984
R_0_8_18_2 Node0_8_18 Node0_9_18 76.99999999999984
R_0_8_18_3 Node0_8_18 Node1_8_18 3153.919999999994
I_0_8_19 GND Node0_8_19 4.516492000000009e-05A
R_0_8_19_1 Node0_8_19 Node0_8_20 76.99999999999984
R_0_8_19_2 Node0_8_19 Node0_9_19 76.99999999999984
R_0_8_19_3 Node0_8_19 Node1_8_19 3153.919999999994
I_0_8_20 GND Node0_8_20 4.3623260000000085e-05A
R_0_8_20_1 Node0_8_20 Node0_8_21 76.99999999999997
R_0_8_20_2 Node0_8_20 Node0_9_20 76.99999999999984
R_0_8_20_3 Node0_8_20 Node1_8_20 3153.919999999994
I_0_8_21 GND Node0_8_21 4.241477999999993e-05A
R_0_8_21_1 Node0_8_21 Node0_8_22 76.99999999999997
R_0_8_21_2 Node0_8_21 Node0_9_21 77.00000000000011
R_0_8_21_3 Node0_8_21 Node1_8_21 3153.920000000006
I_0_8_22 GND Node0_8_22 4.161905000000008e-05A
R_0_8_22_1 Node0_8_22 Node0_8_23 76.99999999999984
R_0_8_22_2 Node0_8_22 Node0_9_22 76.99999999999984
R_0_8_22_3 Node0_8_22 Node1_8_22 3153.919999999994
I_0_8_23 GND Node0_8_23 4.1171390000000084e-05A
R_0_8_23_1 Node0_8_23 Node0_8_24 76.99999999999984
R_0_8_23_2 Node0_8_23 Node0_9_23 76.99999999999984
R_0_8_23_3 Node0_8_23 Node1_8_23 3153.919999999994
I_0_8_24 GND Node0_8_24 4.0954110000000083e-05A
R_0_8_24_1 Node0_8_24 Node0_8_25 76.99999999999984
R_0_8_24_2 Node0_8_24 Node0_9_24 76.99999999999984
R_0_8_24_3 Node0_8_24 Node1_8_24 3153.919999999994
I_0_8_25 GND Node0_8_25 4.086259000000008e-05A
R_0_8_25_1 Node0_8_25 Node0_8_26 76.99999999999984
R_0_8_25_2 Node0_8_25 Node0_9_25 76.99999999999984
R_0_8_25_3 Node0_8_25 Node1_8_25 3153.919999999994
I_0_8_26 GND Node0_8_26 4.082900000000008e-05A
R_0_8_26_1 Node0_8_26 Node0_8_27 76.99999999999984
R_0_8_26_2 Node0_8_26 Node0_9_26 76.99999999999984
R_0_8_26_3 Node0_8_26 Node1_8_26 3153.919999999994
I_0_8_27 GND Node0_8_27 4.081823000000008e-05A
R_0_8_27_1 Node0_8_27 Node0_8_28 76.99999999999984
R_0_8_27_2 Node0_8_27 Node0_9_27 76.99999999999984
R_0_8_27_3 Node0_8_27 Node1_8_27 3153.919999999994
I_0_8_28 GND Node0_8_28 4.0815210000000084e-05A
R_0_8_28_1 Node0_8_28 Node0_8_29 76.99999999999997
R_0_8_28_2 Node0_8_28 Node0_9_28 76.99999999999984
R_0_8_28_3 Node0_8_28 Node1_8_28 3153.919999999994
I_0_8_29 GND Node0_8_29 4.081445999999993e-05A
R_0_8_29_1 Node0_8_29 Node0_8_30 76.99999999999997
R_0_8_29_2 Node0_8_29 Node0_9_29 77.00000000000011
R_0_8_29_3 Node0_8_29 Node1_8_29 3153.920000000006
I_0_8_30 GND Node0_8_30 4.081430000000008e-05A
R_0_8_30_1 Node0_8_30 Node0_8_31 76.99999999999984
R_0_8_30_2 Node0_8_30 Node0_9_30 76.99999999999984
R_0_8_30_3 Node0_8_30 Node1_8_30 3153.919999999994
I_0_8_31 GND Node0_8_31 4.081427000000008e-05A
R_0_8_31_2 Node0_8_31 Node0_9_31 76.99999999999984
R_0_8_31_3 Node0_8_31 Node1_8_31 3153.919999999994
I_0_9_0 GND Node0_9_0 4.0814270000000045e-05A
R_0_9_0_1 Node0_9_0 Node0_9_1 76.99999999999991
R_0_9_0_2 Node0_9_0 Node0_10_0 77.00000000000006
R_0_9_0_3 Node0_9_0 Node1_9_0 3153.9199999999973
I_0_9_1 GND Node0_9_1 4.0814280000000046e-05A
R_0_9_1_1 Node0_9_1 Node0_9_2 76.99999999999991
R_0_9_1_2 Node0_9_1 Node0_10_1 77.00000000000006
R_0_9_1_3 Node0_9_1 Node1_9_1 3153.9199999999973
I_0_9_2 GND Node0_9_2 4.081435000000005e-05A
R_0_9_2_1 Node0_9_2 Node0_9_3 76.99999999999991
R_0_9_2_2 Node0_9_2 Node0_10_2 77.00000000000006
R_0_9_2_3 Node0_9_2 Node1_9_2 3153.9199999999973
I_0_9_3 GND Node0_9_3 4.081471000000005e-05A
R_0_9_3_1 Node0_9_3 Node0_9_4 76.99999999999991
R_0_9_3_2 Node0_9_3 Node0_10_3 77.00000000000006
R_0_9_3_3 Node0_9_3 Node1_9_3 3153.9199999999973
I_0_9_4 GND Node0_9_4 4.0816390000000044e-05A
R_0_9_4_1 Node0_9_4 Node0_9_5 76.99999999999991
R_0_9_4_2 Node0_9_4 Node0_10_4 77.00000000000006
R_0_9_4_3 Node0_9_4 Node1_9_4 3153.9199999999973
I_0_9_5 GND Node0_9_5 4.0823200000000046e-05A
R_0_9_5_1 Node0_9_5 Node0_9_6 76.99999999999991
R_0_9_5_2 Node0_9_5 Node0_10_5 77.00000000000006
R_0_9_5_3 Node0_9_5 Node1_9_5 3153.9199999999973
I_0_9_6 GND Node0_9_6 4.0847480000000044e-05A
R_0_9_6_1 Node0_9_6 Node0_9_7 76.99999999999991
R_0_9_6_2 Node0_9_6 Node0_10_6 77.00000000000006
R_0_9_6_3 Node0_9_6 Node1_9_6 3153.9199999999973
I_0_9_7 GND Node0_9_7 4.092318000000005e-05A
R_0_9_7_1 Node0_9_7 Node0_9_8 76.99999999999989
R_0_9_7_2 Node0_9_7 Node0_10_7 77.00000000000006
R_0_9_7_3 Node0_9_7 Node1_9_7 3153.9199999999973
I_0_9_8 GND Node0_9_8 4.112942000000008e-05A
R_0_9_8_1 Node0_9_8 Node0_9_9 76.99999999999984
R_0_9_8_2 Node0_9_8 Node0_10_8 76.99999999999997
R_0_9_8_3 Node0_9_8 Node1_9_8 3153.919999999994
I_0_9_9 GND Node0_9_9 4.161905000000008e-05A
R_0_9_9_1 Node0_9_9 Node0_9_10 76.99999999999991
R_0_9_9_2 Node0_9_9 Node0_10_9 76.99999999999997
R_0_9_9_3 Node0_9_9 Node1_9_9 3153.919999999994
I_0_9_10 GND Node0_9_10 4.262789e-05A
R_0_9_10_1 Node0_9_10 Node0_9_11 76.99999999999991
R_0_9_10_2 Node0_9_10 Node0_10_10 77.00000000000013
R_0_9_10_3 Node0_9_10 Node1_9_10 3153.9200000000005
I_0_9_11 GND Node0_9_11 4.442108000000009e-05A
R_0_9_11_1 Node0_9_11 Node0_9_12 76.99999999999984
R_0_9_11_2 Node0_9_11 Node0_10_11 76.99999999999997
R_0_9_11_3 Node0_9_11 Node1_9_11 3153.919999999994
I_0_9_12 GND Node0_9_12 4.714443000000009e-05A
R_0_9_12_1 Node0_9_12 Node0_9_13 76.99999999999984
R_0_9_12_2 Node0_9_12 Node0_10_12 76.99999999999997
R_0_9_12_3 Node0_9_12 Node1_9_12 3153.919999999994
I_0_9_13 GND Node0_9_13 5.06186100000001e-05A
R_0_9_13_1 Node0_9_13 Node0_9_14 76.99999999999991
R_0_9_13_2 Node0_9_13 Node0_10_13 76.99999999999997
R_0_9_13_3 Node0_9_13 Node1_9_13 3153.919999999994
I_0_9_14 GND Node0_9_14 5.421522e-05A
R_0_9_14_1 Node0_9_14 Node0_9_15 76.99999999999991
R_0_9_14_2 Node0_9_14 Node0_10_14 77.00000000000013
R_0_9_14_3 Node0_9_14 Node1_9_14 3153.9200000000005
I_0_9_15 GND Node0_9_15 5.697890000000011e-05A
R_0_9_15_1 Node0_9_15 Node0_9_16 76.99999999999984
R_0_9_15_2 Node0_9_15 Node0_10_15 76.99999999999997
R_0_9_15_3 Node0_9_15 Node1_9_15 3153.919999999994
I_0_9_16 GND Node0_9_16 5.802143000000012e-05A
R_0_9_16_1 Node0_9_16 Node0_9_17 76.99999999999984
R_0_9_16_2 Node0_9_16 Node0_10_16 76.99999999999997
R_0_9_16_3 Node0_9_16 Node1_9_16 3153.919999999994
I_0_9_17 GND Node0_9_17 5.697890000000011e-05A
R_0_9_17_1 Node0_9_17 Node0_9_18 76.99999999999984
R_0_9_17_2 Node0_9_17 Node0_10_17 76.99999999999997
R_0_9_17_3 Node0_9_17 Node1_9_17 3153.919999999994
I_0_9_18 GND Node0_9_18 5.4215220000000105e-05A
R_0_9_18_1 Node0_9_18 Node0_9_19 76.99999999999984
R_0_9_18_2 Node0_9_18 Node0_10_18 76.99999999999997
R_0_9_18_3 Node0_9_18 Node1_9_18 3153.919999999994
I_0_9_19 GND Node0_9_19 5.06186100000001e-05A
R_0_9_19_1 Node0_9_19 Node0_9_20 76.99999999999984
R_0_9_19_2 Node0_9_19 Node0_10_19 76.99999999999997
R_0_9_19_3 Node0_9_19 Node1_9_19 3153.919999999994
I_0_9_20 GND Node0_9_20 4.714443000000009e-05A
R_0_9_20_1 Node0_9_20 Node0_9_21 76.99999999999997
R_0_9_20_2 Node0_9_20 Node0_10_20 76.99999999999997
R_0_9_20_3 Node0_9_20 Node1_9_20 3153.919999999994
I_0_9_21 GND Node0_9_21 4.4421079999999925e-05A
R_0_9_21_1 Node0_9_21 Node0_9_22 76.99999999999997
R_0_9_21_2 Node0_9_21 Node0_10_21 77.00000000000026
R_0_9_21_3 Node0_9_21 Node1_9_21 3153.920000000006
I_0_9_22 GND Node0_9_22 4.2627890000000086e-05A
R_0_9_22_1 Node0_9_22 Node0_9_23 76.99999999999984
R_0_9_22_2 Node0_9_22 Node0_10_22 76.99999999999997
R_0_9_22_3 Node0_9_22 Node1_9_22 3153.919999999994
I_0_9_23 GND Node0_9_23 4.161905000000008e-05A
R_0_9_23_1 Node0_9_23 Node0_9_24 76.99999999999984
R_0_9_23_2 Node0_9_23 Node0_10_23 76.99999999999997
R_0_9_23_3 Node0_9_23 Node1_9_23 3153.919999999994
I_0_9_24 GND Node0_9_24 4.112942000000008e-05A
R_0_9_24_1 Node0_9_24 Node0_9_25 76.99999999999984
R_0_9_24_2 Node0_9_24 Node0_10_24 76.99999999999997
R_0_9_24_3 Node0_9_24 Node1_9_24 3153.919999999994
I_0_9_25 GND Node0_9_25 4.092318000000008e-05A
R_0_9_25_1 Node0_9_25 Node0_9_26 76.99999999999984
R_0_9_25_2 Node0_9_25 Node0_10_25 76.99999999999997
R_0_9_25_3 Node0_9_25 Node1_9_25 3153.919999999994
I_0_9_26 GND Node0_9_26 4.084748000000008e-05A
R_0_9_26_1 Node0_9_26 Node0_9_27 76.99999999999984
R_0_9_26_2 Node0_9_26 Node0_10_26 76.99999999999997
R_0_9_26_3 Node0_9_26 Node1_9_26 3153.919999999994
I_0_9_27 GND Node0_9_27 4.082320000000008e-05A
R_0_9_27_1 Node0_9_27 Node0_9_28 76.99999999999984
R_0_9_27_2 Node0_9_27 Node0_10_27 76.99999999999997
R_0_9_27_3 Node0_9_27 Node1_9_27 3153.919999999994
I_0_9_28 GND Node0_9_28 4.081639000000008e-05A
R_0_9_28_1 Node0_9_28 Node0_9_29 76.99999999999997
R_0_9_28_2 Node0_9_28 Node0_10_28 76.99999999999997
R_0_9_28_3 Node0_9_28 Node1_9_28 3153.919999999994
I_0_9_29 GND Node0_9_29 4.0814709999999934e-05A
R_0_9_29_1 Node0_9_29 Node0_9_30 76.99999999999997
R_0_9_29_2 Node0_9_29 Node0_10_29 77.00000000000026
R_0_9_29_3 Node0_9_29 Node1_9_29 3153.920000000006
I_0_9_30 GND Node0_9_30 4.0814350000000085e-05A
R_0_9_30_1 Node0_9_30 Node0_9_31 76.99999999999984
R_0_9_30_2 Node0_9_30 Node0_10_30 76.99999999999997
R_0_9_30_3 Node0_9_30 Node1_9_30 3153.919999999994
I_0_9_31 GND Node0_9_31 4.081428000000008e-05A
R_0_9_31_2 Node0_9_31 Node0_10_31 76.99999999999997
R_0_9_31_3 Node0_9_31 Node1_9_31 3153.919999999994
I_0_10_0 GND Node0_10_0 4.0814269999999896e-05A
R_0_10_0_1 Node0_10_0 Node0_10_1 77.00000000000018
R_0_10_0_2 Node0_10_0 Node0_11_0 77.00000000000006
R_0_10_0_3 Node0_10_0 Node1_10_0 3153.9200000000087
I_0_10_1 GND Node0_10_1 4.08142899999999e-05A
R_0_10_1_1 Node0_10_1 Node0_10_2 77.00000000000018
R_0_10_1_2 Node0_10_1 Node0_11_1 77.00000000000006
R_0_10_1_3 Node0_10_1 Node1_10_1 3153.9200000000087
I_0_10_2 GND Node0_10_2 4.08144299999999e-05A
R_0_10_2_1 Node0_10_2 Node0_10_3 77.00000000000018
R_0_10_2_2 Node0_10_2 Node0_11_2 77.00000000000006
R_0_10_2_3 Node0_10_2 Node1_10_2 3153.9200000000087
I_0_10_3 GND Node0_10_3 4.08151499999999e-05A
R_0_10_3_1 Node0_10_3 Node0_10_4 77.00000000000018
R_0_10_3_2 Node0_10_3 Node0_11_3 77.00000000000006
R_0_10_3_3 Node0_10_3 Node1_10_3 3153.9200000000087
I_0_10_4 GND Node0_10_4 4.08184899999999e-05A
R_0_10_4_1 Node0_10_4 Node0_10_5 77.00000000000018
R_0_10_4_2 Node0_10_4 Node0_11_4 77.00000000000006
R_0_10_4_3 Node0_10_4 Node1_10_4 3153.9200000000087
I_0_10_5 GND Node0_10_5 4.083203999999989e-05A
R_0_10_5_1 Node0_10_5 Node0_10_6 77.00000000000018
R_0_10_5_2 Node0_10_5 Node0_11_5 77.00000000000006
R_0_10_5_3 Node0_10_5 Node1_10_5 3153.9200000000087
I_0_10_6 GND Node0_10_6 4.0880319999999895e-05A
R_0_10_6_1 Node0_10_6 Node0_10_7 77.00000000000018
R_0_10_6_2 Node0_10_6 Node0_11_6 77.00000000000006
R_0_10_6_3 Node0_10_6 Node1_10_6 3153.9200000000087
I_0_10_7 GND Node0_10_7 4.10308699999999e-05A
R_0_10_7_1 Node0_10_7 Node0_10_8 77.00000000000014
R_0_10_7_2 Node0_10_7 Node0_11_7 77.00000000000006
R_0_10_7_3 Node0_10_7 Node1_10_7 3153.9200000000087
I_0_10_8 GND Node0_10_8 4.144102999999993e-05A
R_0_10_8_1 Node0_10_8 Node0_10_9 77.00000000000011
R_0_10_8_2 Node0_10_8 Node0_11_8 76.99999999999997
R_0_10_8_3 Node0_10_8 Node1_10_8 3153.920000000006
I_0_10_9 GND Node0_10_9 4.241477999999993e-05A
R_0_10_9_1 Node0_10_9 Node0_10_10 77.00000000000018
R_0_10_9_2 Node0_10_9 Node0_11_9 76.99999999999997
R_0_10_9_3 Node0_10_9 Node1_10_9 3153.920000000006
I_0_10_10 GND Node0_10_10 4.442107999999985e-05A
R_0_10_10_1 Node0_10_10 Node0_10_11 77.00000000000018
R_0_10_10_2 Node0_10_10 Node0_11_10 77.00000000000013
R_0_10_10_3 Node0_10_10 Node1_10_10 3153.920000000011
I_0_10_11 GND Node0_10_11 4.798727999999992e-05A
R_0_10_11_1 Node0_10_11 Node0_10_12 77.00000000000011
R_0_10_11_2 Node0_10_11 Node0_11_11 76.99999999999997
R_0_10_11_3 Node0_10_11 Node1_10_11 3153.920000000006
I_0_10_12 GND Node0_10_12 5.340329999999991e-05A
R_0_10_12_1 Node0_10_12 Node0_10_13 77.00000000000011
R_0_10_12_2 Node0_10_12 Node0_11_12 76.99999999999997
R_0_10_12_3 Node0_10_12 Node1_10_12 3153.920000000006
I_0_10_13 GND Node0_10_13 6.03125399999999e-05A
R_0_10_13_1 Node0_10_13 Node0_10_14 77.00000000000018
R_0_10_13_2 Node0_10_13 Node0_11_13 76.99999999999997
R_0_10_13_3 Node0_10_13 Node1_10_13 3153.920000000006
I_0_10_14 GND Node0_10_14 6.746523999999976e-05A
R_0_10_14_1 Node0_10_14 Node0_10_15 77.00000000000018
R_0_10_14_2 Node0_10_14 Node0_11_14 77.00000000000013
R_0_10_14_3 Node0_10_14 Node1_10_14 3153.920000000011
I_0_10_15 GND Node0_10_15 7.296147999999988e-05A
R_0_10_15_1 Node0_10_15 Node0_10_16 77.00000000000011
R_0_10_15_2 Node0_10_15 Node0_11_15 76.99999999999997
R_0_10_15_3 Node0_10_15 Node1_10_15 3153.920000000006
I_0_10_16 GND Node0_10_16 7.503479999999988e-05A
R_0_10_16_1 Node0_10_16 Node0_10_17 77.00000000000011
R_0_10_16_2 Node0_10_16 Node0_11_16 76.99999999999997
R_0_10_16_3 Node0_10_16 Node1_10_16 3153.920000000006
I_0_10_17 GND Node0_10_17 7.296147999999988e-05A
R_0_10_17_1 Node0_10_17 Node0_10_18 77.00000000000011
R_0_10_17_2 Node0_10_17 Node0_11_17 76.99999999999997
R_0_10_17_3 Node0_10_17 Node1_10_17 3153.920000000006
I_0_10_18 GND Node0_10_18 6.746523999999989e-05A
R_0_10_18_1 Node0_10_18 Node0_10_19 77.00000000000011
R_0_10_18_2 Node0_10_18 Node0_11_18 76.99999999999997
R_0_10_18_3 Node0_10_18 Node1_10_18 3153.920000000006
I_0_10_19 GND Node0_10_19 6.03125399999999e-05A
R_0_10_19_1 Node0_10_19 Node0_10_20 77.00000000000011
R_0_10_19_2 Node0_10_19 Node0_11_19 76.99999999999997
R_0_10_19_3 Node0_10_19 Node1_10_19 3153.920000000006
I_0_10_20 GND Node0_10_20 5.340329999999991e-05A
R_0_10_20_1 Node0_10_20 Node0_10_21 77.00000000000026
R_0_10_20_2 Node0_10_20 Node0_11_20 76.99999999999997
R_0_10_20_3 Node0_10_20 Node1_10_20 3153.920000000006
I_0_10_21 GND Node0_10_21 4.7987279999999755e-05A
R_0_10_21_1 Node0_10_21 Node0_10_22 77.00000000000026
R_0_10_21_2 Node0_10_21 Node0_11_21 77.00000000000026
R_0_10_21_3 Node0_10_21 Node1_10_21 3153.920000000017
I_0_10_22 GND Node0_10_22 4.4421079999999925e-05A
R_0_10_22_1 Node0_10_22 Node0_10_23 77.00000000000011
R_0_10_22_2 Node0_10_22 Node0_11_22 76.99999999999997
R_0_10_22_3 Node0_10_22 Node1_10_22 3153.920000000006
I_0_10_23 GND Node0_10_23 4.241477999999993e-05A
R_0_10_23_1 Node0_10_23 Node0_10_24 77.00000000000011
R_0_10_23_2 Node0_10_23 Node0_11_23 76.99999999999997
R_0_10_23_3 Node0_10_23 Node1_10_23 3153.920000000006
I_0_10_24 GND Node0_10_24 4.144102999999993e-05A
R_0_10_24_1 Node0_10_24 Node0_10_25 77.00000000000011
R_0_10_24_2 Node0_10_24 Node0_11_24 76.99999999999997
R_0_10_24_3 Node0_10_24 Node1_10_24 3153.920000000006
I_0_10_25 GND Node0_10_25 4.103086999999993e-05A
R_0_10_25_1 Node0_10_25 Node0_10_26 77.00000000000011
R_0_10_25_2 Node0_10_25 Node0_11_25 76.99999999999997
R_0_10_25_3 Node0_10_25 Node1_10_25 3153.920000000006
I_0_10_26 GND Node0_10_26 4.088031999999993e-05A
R_0_10_26_1 Node0_10_26 Node0_10_27 77.00000000000011
R_0_10_26_2 Node0_10_26 Node0_11_26 76.99999999999997
R_0_10_26_3 Node0_10_26 Node1_10_26 3153.920000000006
I_0_10_27 GND Node0_10_27 4.0832039999999926e-05A
R_0_10_27_1 Node0_10_27 Node0_10_28 77.00000000000011
R_0_10_27_2 Node0_10_27 Node0_11_27 76.99999999999997
R_0_10_27_3 Node0_10_27 Node1_10_27 3153.920000000006
I_0_10_28 GND Node0_10_28 4.0818489999999934e-05A
R_0_10_28_1 Node0_10_28 Node0_10_29 77.00000000000026
R_0_10_28_2 Node0_10_28 Node0_11_28 76.99999999999997
R_0_10_28_3 Node0_10_28 Node1_10_28 3153.920000000006
I_0_10_29 GND Node0_10_29 4.081514999999979e-05A
R_0_10_29_1 Node0_10_29 Node0_10_30 77.00000000000026
R_0_10_29_2 Node0_10_29 Node0_11_29 77.00000000000026
R_0_10_29_3 Node0_10_29 Node1_10_29 3153.920000000017
I_0_10_30 GND Node0_10_30 4.0814429999999934e-05A
R_0_10_30_1 Node0_10_30 Node0_10_31 77.00000000000011
R_0_10_30_2 Node0_10_30 Node0_11_30 76.99999999999997
R_0_10_30_3 Node0_10_30 Node1_10_30 3153.920000000006
I_0_10_31 GND Node0_10_31 4.081428999999993e-05A
R_0_10_31_2 Node0_10_31 Node0_11_31 76.99999999999997
R_0_10_31_3 Node0_10_31 Node1_10_31 3153.920000000006
I_0_11_0 GND Node0_11_0 4.0814270000000045e-05A
R_0_11_0_1 Node0_11_0 Node0_11_1 76.99999999999991
R_0_11_0_2 Node0_11_0 Node0_12_0 76.99999999999991
R_0_11_0_3 Node0_11_0 Node1_11_0 3153.9199999999973
I_0_11_1 GND Node0_11_1 4.081431000000004e-05A
R_0_11_1_1 Node0_11_1 Node0_11_2 76.99999999999991
R_0_11_1_2 Node0_11_1 Node0_12_1 76.99999999999991
R_0_11_1_3 Node0_11_1 Node1_11_1 3153.9199999999973
I_0_11_2 GND Node0_11_2 4.0814550000000044e-05A
R_0_11_2_1 Node0_11_2 Node0_11_3 76.99999999999991
R_0_11_2_2 Node0_11_2 Node0_12_2 76.99999999999991
R_0_11_2_3 Node0_11_2 Node1_11_2 3153.9199999999973
I_0_11_3 GND Node0_11_3 4.0815820000000045e-05A
R_0_11_3_1 Node0_11_3 Node0_11_4 76.99999999999991
R_0_11_3_2 Node0_11_3 Node0_12_3 76.99999999999991
R_0_11_3_3 Node0_11_3 Node1_11_3 3153.9199999999973
I_0_11_4 GND Node0_11_4 4.082168000000005e-05A
R_0_11_4_1 Node0_11_4 Node0_11_5 76.99999999999991
R_0_11_4_2 Node0_11_4 Node0_12_4 76.99999999999991
R_0_11_4_3 Node0_11_4 Node1_11_4 3153.9199999999973
I_0_11_5 GND Node0_11_5 4.0845470000000046e-05A
R_0_11_5_1 Node0_11_5 Node0_11_6 76.99999999999991
R_0_11_5_2 Node0_11_5 Node0_12_5 76.99999999999991
R_0_11_5_3 Node0_11_5 Node1_11_5 3153.9199999999973
I_0_11_6 GND Node0_11_6 4.093020000000005e-05A
R_0_11_6_1 Node0_11_6 Node0_11_7 76.99999999999991
R_0_11_6_2 Node0_11_6 Node0_12_6 76.99999999999991
R_0_11_6_3 Node0_11_6 Node1_11_6 3153.9199999999973
I_0_11_7 GND Node0_11_7 4.119442000000005e-05A
R_0_11_7_1 Node0_11_7 Node0_11_8 76.99999999999989
R_0_11_7_2 Node0_11_7 Node0_12_7 76.99999999999991
R_0_11_7_3 Node0_11_7 Node1_11_7 3153.9199999999973
I_0_11_8 GND Node0_11_8 4.191428000000008e-05A
R_0_11_8_1 Node0_11_8 Node0_11_9 76.99999999999984
R_0_11_8_2 Node0_11_8 Node0_12_8 76.99999999999984
R_0_11_8_3 Node0_11_8 Node1_11_8 3153.919999999994
I_0_11_9 GND Node0_11_9 4.3623260000000085e-05A
R_0_11_9_1 Node0_11_9 Node0_11_10 76.99999999999991
R_0_11_9_2 Node0_11_9 Node0_12_9 76.99999999999984
R_0_11_9_3 Node0_11_9 Node1_11_9 3153.919999999994
I_0_11_10 GND Node0_11_10 4.714443e-05A
R_0_11_10_1 Node0_11_10 Node0_11_11 76.99999999999991
R_0_11_10_2 Node0_11_10 Node0_12_10 77.0
R_0_11_10_3 Node0_11_10 Node1_11_10 3153.9200000000005
I_0_11_11 GND Node0_11_11 5.3403300000000106e-05A
R_0_11_11_1 Node0_11_11 Node0_11_12 76.99999999999984
R_0_11_11_2 Node0_11_11 Node0_12_11 76.99999999999984
R_0_11_11_3 Node0_11_11 Node1_11_11 3153.919999999994
I_0_11_12 GND Node0_11_12 6.290870000000012e-05A
R_0_11_12_1 Node0_11_12 Node0_11_13 76.99999999999984
R_0_11_12_2 Node0_11_12 Node0_12_12 76.99999999999984
R_0_11_12_3 Node0_11_12 Node1_11_12 3153.919999999994
I_0_11_13 GND Node0_11_13 7.503480000000015e-05A
R_0_11_13_1 Node0_11_13 Node0_11_14 76.99999999999991
R_0_11_13_2 Node0_11_13 Node0_12_13 76.99999999999984
R_0_11_13_3 Node0_11_13 Node1_11_13 3153.919999999994
I_0_11_14 GND Node0_11_14 8.758819e-05A
R_0_11_14_1 Node0_11_14 Node0_11_15 76.99999999999991
R_0_11_14_2 Node0_11_14 Node0_12_14 77.0
R_0_11_14_3 Node0_11_14 Node1_11_14 3153.9200000000005
I_0_11_15 GND Node0_11_15 9.723439000000019e-05A
R_0_11_15_1 Node0_11_15 Node0_11_16 76.99999999999984
R_0_11_15_2 Node0_11_15 Node0_12_15 76.99999999999984
R_0_11_15_3 Node0_11_15 Node1_11_15 3153.919999999994
I_0_11_16 GND Node0_11_16 0.0001008732000000002A
R_0_11_16_1 Node0_11_16 Node0_11_17 76.99999999999984
R_0_11_16_2 Node0_11_16 Node0_12_16 76.99999999999984
R_0_11_16_3 Node0_11_16 Node1_11_16 3153.919999999994
I_0_11_17 GND Node0_11_17 9.723439000000019e-05A
R_0_11_17_1 Node0_11_17 Node0_11_18 76.99999999999984
R_0_11_17_2 Node0_11_17 Node0_12_17 76.99999999999984
R_0_11_17_3 Node0_11_17 Node1_11_17 3153.919999999994
I_0_11_18 GND Node0_11_18 8.758819000000018e-05A
R_0_11_18_1 Node0_11_18 Node0_11_19 76.99999999999984
R_0_11_18_2 Node0_11_18 Node0_12_18 76.99999999999984
R_0_11_18_3 Node0_11_18 Node1_11_18 3153.919999999994
I_0_11_19 GND Node0_11_19 7.503480000000015e-05A
R_0_11_19_1 Node0_11_19 Node0_11_20 76.99999999999984
R_0_11_19_2 Node0_11_19 Node0_12_19 76.99999999999984
R_0_11_19_3 Node0_11_19 Node1_11_19 3153.919999999994
I_0_11_20 GND Node0_11_20 6.290870000000012e-05A
R_0_11_20_1 Node0_11_20 Node0_11_21 76.99999999999997
R_0_11_20_2 Node0_11_20 Node0_12_20 76.99999999999984
R_0_11_20_3 Node0_11_20 Node1_11_20 3153.919999999994
I_0_11_21 GND Node0_11_21 5.340329999999991e-05A
R_0_11_21_1 Node0_11_21 Node0_11_22 76.99999999999997
R_0_11_21_2 Node0_11_21 Node0_12_21 77.00000000000011
R_0_11_21_3 Node0_11_21 Node1_11_21 3153.920000000006
I_0_11_22 GND Node0_11_22 4.714443000000009e-05A
R_0_11_22_1 Node0_11_22 Node0_11_23 76.99999999999984
R_0_11_22_2 Node0_11_22 Node0_12_22 76.99999999999984
R_0_11_22_3 Node0_11_22 Node1_11_22 3153.919999999994
I_0_11_23 GND Node0_11_23 4.3623260000000085e-05A
R_0_11_23_1 Node0_11_23 Node0_11_24 76.99999999999984
R_0_11_23_2 Node0_11_23 Node0_12_23 76.99999999999984
R_0_11_23_3 Node0_11_23 Node1_11_23 3153.919999999994
I_0_11_24 GND Node0_11_24 4.191428000000008e-05A
R_0_11_24_1 Node0_11_24 Node0_11_25 76.99999999999984
R_0_11_24_2 Node0_11_24 Node0_12_24 76.99999999999984
R_0_11_24_3 Node0_11_24 Node1_11_24 3153.919999999994
I_0_11_25 GND Node0_11_25 4.119442000000008e-05A
R_0_11_25_1 Node0_11_25 Node0_11_26 76.99999999999984
R_0_11_25_2 Node0_11_25 Node0_12_25 76.99999999999984
R_0_11_25_3 Node0_11_25 Node1_11_25 3153.919999999994
I_0_11_26 GND Node0_11_26 4.0930200000000085e-05A
R_0_11_26_1 Node0_11_26 Node0_11_27 76.99999999999984
R_0_11_26_2 Node0_11_26 Node0_12_26 76.99999999999984
R_0_11_26_3 Node0_11_26 Node1_11_26 3153.919999999994
I_0_11_27 GND Node0_11_27 4.084547000000008e-05A
R_0_11_27_1 Node0_11_27 Node0_11_28 76.99999999999984
R_0_11_27_2 Node0_11_27 Node0_12_27 76.99999999999984
R_0_11_27_3 Node0_11_27 Node1_11_27 3153.919999999994
I_0_11_28 GND Node0_11_28 4.082168000000008e-05A
R_0_11_28_1 Node0_11_28 Node0_11_29 76.99999999999997
R_0_11_28_2 Node0_11_28 Node0_12_28 76.99999999999984
R_0_11_28_3 Node0_11_28 Node1_11_28 3153.919999999994
I_0_11_29 GND Node0_11_29 4.081581999999993e-05A
R_0_11_29_1 Node0_11_29 Node0_11_30 76.99999999999997
R_0_11_29_2 Node0_11_29 Node0_12_29 77.00000000000011
R_0_11_29_3 Node0_11_29 Node1_11_29 3153.920000000006
I_0_11_30 GND Node0_11_30 4.081455000000008e-05A
R_0_11_30_1 Node0_11_30 Node0_11_31 76.99999999999984
R_0_11_30_2 Node0_11_30 Node0_12_30 76.99999999999984
R_0_11_30_3 Node0_11_30 Node1_11_30 3153.919999999994
I_0_11_31 GND Node0_11_31 4.0814310000000075e-05A
R_0_11_31_2 Node0_11_31 Node0_12_31 76.99999999999984
R_0_11_31_3 Node0_11_31 Node1_11_31 3153.919999999994
I_0_12_0 GND Node0_12_0 4.0814270000000045e-05A
R_0_12_0_1 Node0_12_0 Node0_12_1 76.99999999999991
R_0_12_0_2 Node0_12_0 Node0_13_0 76.99999999999991
R_0_12_0_3 Node0_12_0 Node1_12_0 3153.9199999999973
I_0_12_1 GND Node0_12_1 4.081434000000005e-05A
R_0_12_1_1 Node0_12_1 Node0_12_2 76.99999999999991
R_0_12_1_2 Node0_12_1 Node0_13_1 76.99999999999991
R_0_12_1_3 Node0_12_1 Node1_12_1 3153.9199999999973
I_0_12_2 GND Node0_12_2 4.081471000000005e-05A
R_0_12_2_1 Node0_12_2 Node0_12_3 76.99999999999991
R_0_12_2_2 Node0_12_2 Node0_13_2 76.99999999999991
R_0_12_2_3 Node0_12_2 Node1_12_2 3153.9199999999973
I_0_12_3 GND Node0_12_3 4.081667000000005e-05A
R_0_12_3_1 Node0_12_3 Node0_12_4 76.99999999999991
R_0_12_3_2 Node0_12_3 Node0_13_3 76.99999999999991
R_0_12_3_3 Node0_12_3 Node1_12_3 3153.9199999999973
I_0_12_4 GND Node0_12_4 4.082574000000005e-05A
R_0_12_4_1 Node0_12_4 Node0_12_5 76.99999999999991
R_0_12_4_2 Node0_12_4 Node0_13_4 76.99999999999991
R_0_12_4_3 Node0_12_4 Node1_12_4 3153.9199999999973
I_0_12_5 GND Node0_12_5 4.0862590000000044e-05A
R_0_12_5_1 Node0_12_5 Node0_12_6 76.99999999999991
R_0_12_5_2 Node0_12_5 Node0_13_5 76.99999999999991
R_0_12_5_3 Node0_12_5 Node1_12_5 3153.9199999999973
I_0_12_6 GND Node0_12_6 4.099384000000005e-05A
R_0_12_6_1 Node0_12_6 Node0_12_7 76.99999999999991
R_0_12_6_2 Node0_12_6 Node0_13_6 76.99999999999991
R_0_12_6_3 Node0_12_6 Node1_12_6 3153.9199999999973
I_0_12_7 GND Node0_12_7 4.140306000000005e-05A
R_0_12_7_1 Node0_12_7 Node0_12_8 76.99999999999989
R_0_12_7_2 Node0_12_7 Node0_13_7 76.99999999999991
R_0_12_7_3 Node0_12_7 Node1_12_7 3153.9199999999973
I_0_12_8 GND Node0_12_8 4.251800000000009e-05A
R_0_12_8_1 Node0_12_8 Node0_12_9 76.99999999999984
R_0_12_8_2 Node0_12_8 Node0_13_8 76.99999999999984
R_0_12_8_3 Node0_12_8 Node1_12_8 3153.919999999994
I_0_12_9 GND Node0_12_9 4.516492000000009e-05A
R_0_12_9_1 Node0_12_9 Node0_12_10 76.99999999999991
R_0_12_9_2 Node0_12_9 Node0_13_9 76.99999999999984
R_0_12_9_3 Node0_12_9 Node1_12_9 3153.919999999994
I_0_12_10 GND Node0_12_10 5.061861e-05A
R_0_12_10_1 Node0_12_10 Node0_12_11 76.99999999999991
R_0_12_10_2 Node0_12_10 Node0_13_10 77.0
R_0_12_10_3 Node0_12_10 Node1_12_10 3153.9200000000005
I_0_12_11 GND Node0_12_11 6.031254000000012e-05A
R_0_12_11_1 Node0_12_11 Node0_12_12 76.99999999999984
R_0_12_11_2 Node0_12_11 Node0_13_11 76.99999999999984
R_0_12_11_3 Node0_12_11 Node1_12_11 3153.919999999994
I_0_12_12 GND Node0_12_12 7.503480000000015e-05A
R_0_12_12_1 Node0_12_12 Node0_12_13 76.99999999999984
R_0_12_12_2 Node0_12_12 Node0_13_12 76.99999999999984
R_0_12_12_3 Node0_12_12 Node1_12_12 3153.919999999994
I_0_12_13 GND Node0_12_13 9.381607000000019e-05A
R_0_12_13_1 Node0_12_13 Node0_12_14 76.99999999999991
R_0_12_13_2 Node0_12_13 Node0_13_13 76.99999999999984
R_0_12_13_3 Node0_12_13 Node1_12_13 3153.919999999994
I_0_12_14 GND Node0_12_14 0.0001132591A
R_0_12_14_1 Node0_12_14 Node0_12_15 76.99999999999991
R_0_12_14_2 Node0_12_14 Node0_13_14 77.0
R_0_12_14_3 Node0_12_14 Node1_12_14 3153.9200000000005
I_0_12_15 GND Node0_12_15 0.00012819950000000024A
R_0_12_15_1 Node0_12_15 Node0_12_16 76.99999999999984
R_0_12_15_2 Node0_12_15 Node0_13_15 76.99999999999984
R_0_12_15_3 Node0_12_15 Node1_12_15 3153.919999999994
I_0_12_16 GND Node0_12_16 0.00013383530000000027A
R_0_12_16_1 Node0_12_16 Node0_12_17 76.99999999999984
R_0_12_16_2 Node0_12_16 Node0_13_16 76.99999999999984
R_0_12_16_3 Node0_12_16 Node1_12_16 3153.919999999994
I_0_12_17 GND Node0_12_17 0.00012819950000000024A
R_0_12_17_1 Node0_12_17 Node0_12_18 76.99999999999984
R_0_12_17_2 Node0_12_17 Node0_13_17 76.99999999999984
R_0_12_17_3 Node0_12_17 Node1_12_17 3153.919999999994
I_0_12_18 GND Node0_12_18 0.00011325910000000023A
R_0_12_18_1 Node0_12_18 Node0_12_19 76.99999999999984
R_0_12_18_2 Node0_12_18 Node0_13_18 76.99999999999984
R_0_12_18_3 Node0_12_18 Node1_12_18 3153.919999999994
I_0_12_19 GND Node0_12_19 9.381607000000019e-05A
R_0_12_19_1 Node0_12_19 Node0_12_20 76.99999999999984
R_0_12_19_2 Node0_12_19 Node0_13_19 76.99999999999984
R_0_12_19_3 Node0_12_19 Node1_12_19 3153.919999999994
I_0_12_20 GND Node0_12_20 7.503480000000015e-05A
R_0_12_20_1 Node0_12_20 Node0_12_21 76.99999999999997
R_0_12_20_2 Node0_12_20 Node0_13_20 76.99999999999984
R_0_12_20_3 Node0_12_20 Node1_12_20 3153.919999999994
I_0_12_21 GND Node0_12_21 6.03125399999999e-05A
R_0_12_21_1 Node0_12_21 Node0_12_22 76.99999999999997
R_0_12_21_2 Node0_12_21 Node0_13_21 77.00000000000011
R_0_12_21_3 Node0_12_21 Node1_12_21 3153.920000000006
I_0_12_22 GND Node0_12_22 5.06186100000001e-05A
R_0_12_22_1 Node0_12_22 Node0_12_23 76.99999999999984
R_0_12_22_2 Node0_12_22 Node0_13_22 76.99999999999984
R_0_12_22_3 Node0_12_22 Node1_12_22 3153.919999999994
I_0_12_23 GND Node0_12_23 4.516492000000009e-05A
R_0_12_23_1 Node0_12_23 Node0_12_24 76.99999999999984
R_0_12_23_2 Node0_12_23 Node0_13_23 76.99999999999984
R_0_12_23_3 Node0_12_23 Node1_12_23 3153.919999999994
I_0_12_24 GND Node0_12_24 4.251800000000009e-05A
R_0_12_24_1 Node0_12_24 Node0_12_25 76.99999999999984
R_0_12_24_2 Node0_12_24 Node0_13_24 76.99999999999984
R_0_12_24_3 Node0_12_24 Node1_12_24 3153.919999999994
I_0_12_25 GND Node0_12_25 4.140306000000008e-05A
R_0_12_25_1 Node0_12_25 Node0_12_26 76.99999999999984
R_0_12_25_2 Node0_12_25 Node0_13_25 76.99999999999984
R_0_12_25_3 Node0_12_25 Node1_12_25 3153.919999999994
I_0_12_26 GND Node0_12_26 4.0993840000000085e-05A
R_0_12_26_1 Node0_12_26 Node0_12_27 76.99999999999984
R_0_12_26_2 Node0_12_26 Node0_13_26 76.99999999999984
R_0_12_26_3 Node0_12_26 Node1_12_26 3153.919999999994
I_0_12_27 GND Node0_12_27 4.086259000000008e-05A
R_0_12_27_1 Node0_12_27 Node0_12_28 76.99999999999984
R_0_12_27_2 Node0_12_27 Node0_13_27 76.99999999999984
R_0_12_27_3 Node0_12_27 Node1_12_27 3153.919999999994
I_0_12_28 GND Node0_12_28 4.082574000000008e-05A
R_0_12_28_1 Node0_12_28 Node0_12_29 76.99999999999997
R_0_12_28_2 Node0_12_28 Node0_13_28 76.99999999999984
R_0_12_28_3 Node0_12_28 Node1_12_28 3153.919999999994
I_0_12_29 GND Node0_12_29 4.0816669999999935e-05A
R_0_12_29_1 Node0_12_29 Node0_12_30 76.99999999999997
R_0_12_29_2 Node0_12_29 Node0_13_29 77.00000000000011
R_0_12_29_3 Node0_12_29 Node1_12_29 3153.920000000006
I_0_12_30 GND Node0_12_30 4.081471000000008e-05A
R_0_12_30_1 Node0_12_30 Node0_12_31 76.99999999999984
R_0_12_30_2 Node0_12_30 Node0_13_30 76.99999999999984
R_0_12_30_3 Node0_12_30 Node1_12_30 3153.919999999994
I_0_12_31 GND Node0_12_31 4.0814340000000084e-05A
R_0_12_31_2 Node0_12_31 Node0_13_31 76.99999999999984
R_0_12_31_3 Node0_12_31 Node1_12_31 3153.919999999994
I_0_13_0 GND Node0_13_0 4.0814280000000046e-05A
R_0_13_0_1 Node0_13_0 Node0_13_1 76.99999999999991
R_0_13_0_2 Node0_13_0 Node0_14_0 76.99999999999991
R_0_13_0_3 Node0_13_0 Node1_13_0 3153.9199999999973
I_0_13_1 GND Node0_13_1 4.0814360000000045e-05A
R_0_13_1_1 Node0_13_1 Node0_13_2 76.99999999999991
R_0_13_1_2 Node0_13_1 Node0_14_1 76.99999999999991
R_0_13_1_3 Node0_13_1 Node1_13_1 3153.9199999999973
I_0_13_2 GND Node0_13_2 4.0814870000000047e-05A
R_0_13_2_1 Node0_13_2 Node0_13_3 76.99999999999991
R_0_13_2_2 Node0_13_2 Node0_14_2 76.99999999999991
R_0_13_2_3 Node0_13_2 Node1_13_2 3153.9199999999973
I_0_13_3 GND Node0_13_3 4.0817550000000044e-05A
R_0_13_3_1 Node0_13_3 Node0_13_4 76.99999999999991
R_0_13_3_2 Node0_13_3 Node0_14_3 76.99999999999991
R_0_13_3_3 Node0_13_3 Node1_13_3 3153.9199999999973
I_0_13_4 GND Node0_13_4 4.0829950000000044e-05A
R_0_13_4_1 Node0_13_4 Node0_13_5 76.99999999999991
R_0_13_4_2 Node0_13_4 Node0_14_4 76.99999999999991
R_0_13_4_3 Node0_13_4 Node1_13_4 3153.9199999999973
I_0_13_5 GND Node0_13_5 4.0880320000000044e-05A
R_0_13_5_1 Node0_13_5 Node0_13_6 76.99999999999991
R_0_13_5_2 Node0_13_5 Node0_14_5 76.99999999999991
R_0_13_5_3 Node0_13_5 Node1_13_5 3153.9199999999973
I_0_13_6 GND Node0_13_6 4.105971000000005e-05A
R_0_13_6_1 Node0_13_6 Node0_13_7 76.99999999999991
R_0_13_6_2 Node0_13_6 Node0_14_6 76.99999999999991
R_0_13_6_3 Node0_13_6 Node1_13_6 3153.9199999999973
I_0_13_7 GND Node0_13_7 4.161905000000005e-05A
R_0_13_7_1 Node0_13_7 Node0_13_8 76.99999999999989
R_0_13_7_2 Node0_13_7 Node0_14_7 76.99999999999991
R_0_13_7_3 Node0_13_7 Node1_13_7 3153.9199999999973
I_0_13_8 GND Node0_13_8 4.3143000000000085e-05A
R_0_13_8_1 Node0_13_8 Node0_13_9 76.99999999999984
R_0_13_8_2 Node0_13_8 Node0_14_8 76.99999999999984
R_0_13_8_3 Node0_13_8 Node1_13_8 3153.919999999994
I_0_13_9 GND Node0_13_9 4.6760900000000096e-05A
R_0_13_9_1 Node0_13_9 Node0_13_10 76.99999999999991
R_0_13_9_2 Node0_13_9 Node0_14_9 76.99999999999984
R_0_13_9_3 Node0_13_9 Node1_13_9 3153.919999999994
I_0_13_10 GND Node0_13_10 5.421522e-05A
R_0_13_10_1 Node0_13_10 Node0_13_11 76.99999999999991
R_0_13_10_2 Node0_13_10 Node0_14_10 77.0
R_0_13_10_3 Node0_13_10 Node1_13_10 3153.9200000000005
I_0_13_11 GND Node0_13_11 6.746524000000013e-05A
R_0_13_11_1 Node0_13_11 Node0_13_12 76.99999999999984
R_0_13_11_2 Node0_13_11 Node0_14_11 76.99999999999984
R_0_13_11_3 Node0_13_11 Node1_13_11 3153.919999999994
I_0_13_12 GND Node0_13_12 8.758819000000018e-05A
R_0_13_12_1 Node0_13_12 Node0_13_13 76.99999999999984
R_0_13_12_2 Node0_13_12 Node0_14_12 76.99999999999984
R_0_13_12_3 Node0_13_12 Node1_13_12 3153.919999999994
I_0_13_13 GND Node0_13_13 0.00011325910000000023A
R_0_13_13_1 Node0_13_13 Node0_13_14 76.99999999999991
R_0_13_13_2 Node0_13_13 Node0_14_13 76.99999999999984
R_0_13_13_3 Node0_13_13 Node1_13_13 3153.919999999994
I_0_13_14 GND Node0_13_14 0.0001398347A
R_0_13_14_1 Node0_13_14 Node0_13_15 76.99999999999991
R_0_13_14_2 Node0_13_14 Node0_14_14 77.0
R_0_13_14_3 Node0_13_14 Node1_13_14 3153.9200000000005
I_0_13_15 GND Node0_13_15 0.00016025570000000034A
R_0_13_15_1 Node0_13_15 Node0_13_16 76.99999999999984
R_0_13_15_2 Node0_13_15 Node0_14_15 76.99999999999984
R_0_13_15_3 Node0_13_15 Node1_13_15 3153.919999999994
I_0_13_16 GND Node0_13_16 0.00016795900000000032A
R_0_13_16_1 Node0_13_16 Node0_13_17 76.99999999999984
R_0_13_16_2 Node0_13_16 Node0_14_16 76.99999999999984
R_0_13_16_3 Node0_13_16 Node1_13_16 3153.919999999994
I_0_13_17 GND Node0_13_17 0.00016025570000000034A
R_0_13_17_1 Node0_13_17 Node0_13_18 76.99999999999984
R_0_13_17_2 Node0_13_17 Node0_14_17 76.99999999999984
R_0_13_17_3 Node0_13_17 Node1_13_17 3153.919999999994
I_0_13_18 GND Node0_13_18 0.00013983470000000027A
R_0_13_18_1 Node0_13_18 Node0_13_19 76.99999999999984
R_0_13_18_2 Node0_13_18 Node0_14_18 76.99999999999984
R_0_13_18_3 Node0_13_18 Node1_13_18 3153.919999999994
I_0_13_19 GND Node0_13_19 0.00011325910000000023A
R_0_13_19_1 Node0_13_19 Node0_13_20 76.99999999999984
R_0_13_19_2 Node0_13_19 Node0_14_19 76.99999999999984
R_0_13_19_3 Node0_13_19 Node1_13_19 3153.919999999994
I_0_13_20 GND Node0_13_20 8.758819000000018e-05A
R_0_13_20_1 Node0_13_20 Node0_13_21 76.99999999999997
R_0_13_20_2 Node0_13_20 Node0_14_20 76.99999999999984
R_0_13_20_3 Node0_13_20 Node1_13_20 3153.919999999994
I_0_13_21 GND Node0_13_21 6.746523999999989e-05A
R_0_13_21_1 Node0_13_21 Node0_13_22 76.99999999999997
R_0_13_21_2 Node0_13_21 Node0_14_21 77.00000000000011
R_0_13_21_3 Node0_13_21 Node1_13_21 3153.920000000006
I_0_13_22 GND Node0_13_22 5.4215220000000105e-05A
R_0_13_22_1 Node0_13_22 Node0_13_23 76.99999999999984
R_0_13_22_2 Node0_13_22 Node0_14_22 76.99999999999984
R_0_13_22_3 Node0_13_22 Node1_13_22 3153.919999999994
I_0_13_23 GND Node0_13_23 4.6760900000000096e-05A
R_0_13_23_1 Node0_13_23 Node0_13_24 76.99999999999984
R_0_13_23_2 Node0_13_23 Node0_14_23 76.99999999999984
R_0_13_23_3 Node0_13_23 Node1_13_23 3153.919999999994
I_0_13_24 GND Node0_13_24 4.3143000000000085e-05A
R_0_13_24_1 Node0_13_24 Node0_13_25 76.99999999999984
R_0_13_24_2 Node0_13_24 Node0_14_24 76.99999999999984
R_0_13_24_3 Node0_13_24 Node1_13_24 3153.919999999994
I_0_13_25 GND Node0_13_25 4.161905000000008e-05A
R_0_13_25_1 Node0_13_25 Node0_13_26 76.99999999999984
R_0_13_25_2 Node0_13_25 Node0_14_25 76.99999999999984
R_0_13_25_3 Node0_13_25 Node1_13_25 3153.919999999994
I_0_13_26 GND Node0_13_26 4.1059710000000085e-05A
R_0_13_26_1 Node0_13_26 Node0_13_27 76.99999999999984
R_0_13_26_2 Node0_13_26 Node0_14_26 76.99999999999984
R_0_13_26_3 Node0_13_26 Node1_13_26 3153.919999999994
I_0_13_27 GND Node0_13_27 4.088032000000008e-05A
R_0_13_27_1 Node0_13_27 Node0_13_28 76.99999999999984
R_0_13_27_2 Node0_13_27 Node0_14_27 76.99999999999984
R_0_13_27_3 Node0_13_27 Node1_13_27 3153.919999999994
I_0_13_28 GND Node0_13_28 4.082995000000008e-05A
R_0_13_28_1 Node0_13_28 Node0_13_29 76.99999999999997
R_0_13_28_2 Node0_13_28 Node0_14_28 76.99999999999984
R_0_13_28_3 Node0_13_28 Node1_13_28 3153.919999999994
I_0_13_29 GND Node0_13_29 4.081754999999993e-05A
R_0_13_29_1 Node0_13_29 Node0_13_30 76.99999999999997
R_0_13_29_2 Node0_13_29 Node0_14_29 77.00000000000011
R_0_13_29_3 Node0_13_29 Node1_13_29 3153.920000000006
I_0_13_30 GND Node0_13_30 4.081487000000008e-05A
R_0_13_30_1 Node0_13_30 Node0_13_31 76.99999999999984
R_0_13_30_2 Node0_13_30 Node0_14_30 76.99999999999984
R_0_13_30_3 Node0_13_30 Node1_13_30 3153.919999999994
I_0_13_31 GND Node0_13_31 4.081436000000008e-05A
R_0_13_31_2 Node0_13_31 Node0_14_31 76.99999999999984
R_0_13_31_3 Node0_13_31 Node1_13_31 3153.919999999994
I_0_14_0 GND Node0_14_0 4.0814280000000046e-05A
R_0_14_0_1 Node0_14_0 Node0_14_1 76.99999999999991
R_0_14_0_2 Node0_14_0 Node0_15_0 76.99999999999991
R_0_14_0_3 Node0_14_0 Node1_14_0 3153.9199999999973
I_0_14_1 GND Node0_14_1 4.0814380000000046e-05A
R_0_14_1_1 Node0_14_1 Node0_14_2 76.99999999999991
R_0_14_1_2 Node0_14_1 Node0_15_1 76.99999999999991
R_0_14_1_3 Node0_14_1 Node1_14_1 3153.9199999999973
I_0_14_2 GND Node0_14_2 4.081500000000005e-05A
R_0_14_2_1 Node0_14_2 Node0_14_3 76.99999999999991
R_0_14_2_2 Node0_14_2 Node0_15_2 76.99999999999991
R_0_14_2_3 Node0_14_2 Node1_14_2 3153.9199999999973
I_0_14_3 GND Node0_14_3 4.0818230000000044e-05A
R_0_14_3_1 Node0_14_3 Node0_14_4 76.99999999999991
R_0_14_3_2 Node0_14_3 Node0_15_3 76.99999999999991
R_0_14_3_3 Node0_14_3 Node1_14_3 3153.9199999999973
I_0_14_4 GND Node0_14_4 4.083319000000005e-05A
R_0_14_4_1 Node0_14_4 Node0_14_5 76.99999999999991
R_0_14_4_2 Node0_14_4 Node0_15_4 76.99999999999991
R_0_14_4_3 Node0_14_4 Node1_14_4 3153.9199999999973
I_0_14_5 GND Node0_14_5 4.089395000000005e-05A
R_0_14_5_1 Node0_14_5 Node0_14_6 76.99999999999991
R_0_14_5_2 Node0_14_5 Node0_15_5 76.99999999999991
R_0_14_5_3 Node0_14_5 Node1_14_5 3153.9199999999973
I_0_14_6 GND Node0_14_6 4.111033000000005e-05A
R_0_14_6_1 Node0_14_6 Node0_14_7 76.99999999999991
R_0_14_6_2 Node0_14_6 Node0_15_6 76.99999999999991
R_0_14_6_3 Node0_14_6 Node1_14_6 3153.9199999999973
I_0_14_7 GND Node0_14_7 4.178503000000005e-05A
R_0_14_7_1 Node0_14_7 Node0_14_8 76.99999999999989
R_0_14_7_2 Node0_14_7 Node0_15_7 76.99999999999991
R_0_14_7_3 Node0_14_7 Node1_14_7 3153.9199999999973
I_0_14_8 GND Node0_14_8 4.3623260000000085e-05A
R_0_14_8_1 Node0_14_8 Node0_14_9 76.99999999999984
R_0_14_8_2 Node0_14_8 Node0_15_8 76.99999999999984
R_0_14_8_3 Node0_14_8 Node1_14_8 3153.919999999994
I_0_14_9 GND Node0_14_9 4.7987280000000094e-05A
R_0_14_9_1 Node0_14_9 Node0_14_10 76.99999999999991
R_0_14_9_2 Node0_14_9 Node0_15_9 76.99999999999984
R_0_14_9_3 Node0_14_9 Node1_14_9 3153.919999999994
I_0_14_10 GND Node0_14_10 5.69789e-05A
R_0_14_10_1 Node0_14_10 Node0_14_11 76.99999999999991
R_0_14_10_2 Node0_14_10 Node0_15_10 77.0
R_0_14_10_3 Node0_14_10 Node1_14_10 3153.9200000000005
I_0_14_11 GND Node0_14_11 7.296148000000015e-05A
R_0_14_11_1 Node0_14_11 Node0_14_12 76.99999999999984
R_0_14_11_2 Node0_14_11 Node0_15_11 76.99999999999984
R_0_14_11_3 Node0_14_11 Node1_14_11 3153.919999999994
I_0_14_12 GND Node0_14_12 9.723439000000019e-05A
R_0_14_12_1 Node0_14_12 Node0_14_13 76.99999999999984
R_0_14_12_2 Node0_14_12 Node0_15_12 76.99999999999984
R_0_14_12_3 Node0_14_12 Node1_14_12 3153.919999999994
I_0_14_13 GND Node0_14_13 0.00012819950000000024A
R_0_14_13_1 Node0_14_13 Node0_14_14 76.99999999999991
R_0_14_13_2 Node0_14_13 Node0_15_13 76.99999999999984
R_0_14_13_3 Node0_14_13 Node1_14_13 3153.919999999994
I_0_14_14 GND Node0_14_14 0.0001602557A
R_0_14_14_1 Node0_14_14 Node0_14_15 76.99999999999991
R_0_14_14_2 Node0_14_14 Node0_15_14 77.0
R_0_14_14_3 Node0_14_14 Node1_14_14 3153.9200000000005
I_0_14_15 GND Node0_14_15 0.00018488810000000038A
R_0_14_15_1 Node0_14_15 Node0_14_16 76.99999999999984
R_0_14_15_2 Node0_14_15 Node0_15_15 76.99999999999984
R_0_14_15_3 Node0_14_15 Node1_14_15 3153.919999999994
I_0_14_16 GND Node0_14_16 0.00019418010000000037A
R_0_14_16_1 Node0_14_16 Node0_14_17 76.99999999999984
R_0_14_16_2 Node0_14_16 Node0_15_16 76.99999999999984
R_0_14_16_3 Node0_14_16 Node1_14_16 3153.919999999994
I_0_14_17 GND Node0_14_17 0.00018488810000000038A
R_0_14_17_1 Node0_14_17 Node0_14_18 76.99999999999984
R_0_14_17_2 Node0_14_17 Node0_15_17 76.99999999999984
R_0_14_17_3 Node0_14_17 Node1_14_17 3153.919999999994
I_0_14_18 GND Node0_14_18 0.00016025570000000034A
R_0_14_18_1 Node0_14_18 Node0_14_19 76.99999999999984
R_0_14_18_2 Node0_14_18 Node0_15_18 76.99999999999984
R_0_14_18_3 Node0_14_18 Node1_14_18 3153.919999999994
I_0_14_19 GND Node0_14_19 0.00012819950000000024A
R_0_14_19_1 Node0_14_19 Node0_14_20 76.99999999999984
R_0_14_19_2 Node0_14_19 Node0_15_19 76.99999999999984
R_0_14_19_3 Node0_14_19 Node1_14_19 3153.919999999994
I_0_14_20 GND Node0_14_20 9.723439000000019e-05A
R_0_14_20_1 Node0_14_20 Node0_14_21 76.99999999999997
R_0_14_20_2 Node0_14_20 Node0_15_20 76.99999999999984
R_0_14_20_3 Node0_14_20 Node1_14_20 3153.919999999994
I_0_14_21 GND Node0_14_21 7.296147999999988e-05A
R_0_14_21_1 Node0_14_21 Node0_14_22 76.99999999999997
R_0_14_21_2 Node0_14_21 Node0_15_21 77.00000000000011
R_0_14_21_3 Node0_14_21 Node1_14_21 3153.920000000006
I_0_14_22 GND Node0_14_22 5.697890000000011e-05A
R_0_14_22_1 Node0_14_22 Node0_14_23 76.99999999999984
R_0_14_22_2 Node0_14_22 Node0_15_22 76.99999999999984
R_0_14_22_3 Node0_14_22 Node1_14_22 3153.919999999994
I_0_14_23 GND Node0_14_23 4.7987280000000094e-05A
R_0_14_23_1 Node0_14_23 Node0_14_24 76.99999999999984
R_0_14_23_2 Node0_14_23 Node0_15_23 76.99999999999984
R_0_14_23_3 Node0_14_23 Node1_14_23 3153.919999999994
I_0_14_24 GND Node0_14_24 4.3623260000000085e-05A
R_0_14_24_1 Node0_14_24 Node0_14_25 76.99999999999984
R_0_14_24_2 Node0_14_24 Node0_15_24 76.99999999999984
R_0_14_24_3 Node0_14_24 Node1_14_24 3153.919999999994
I_0_14_25 GND Node0_14_25 4.1785030000000084e-05A
R_0_14_25_1 Node0_14_25 Node0_14_26 76.99999999999984
R_0_14_25_2 Node0_14_25 Node0_15_25 76.99999999999984
R_0_14_25_3 Node0_14_25 Node1_14_25 3153.919999999994
I_0_14_26 GND Node0_14_26 4.111033000000008e-05A
R_0_14_26_1 Node0_14_26 Node0_14_27 76.99999999999984
R_0_14_26_2 Node0_14_26 Node0_15_26 76.99999999999984
R_0_14_26_3 Node0_14_26 Node1_14_26 3153.919999999994
I_0_14_27 GND Node0_14_27 4.089395000000008e-05A
R_0_14_27_1 Node0_14_27 Node0_14_28 76.99999999999984
R_0_14_27_2 Node0_14_27 Node0_15_27 76.99999999999984
R_0_14_27_3 Node0_14_27 Node1_14_27 3153.919999999994
I_0_14_28 GND Node0_14_28 4.083319000000008e-05A
R_0_14_28_1 Node0_14_28 Node0_14_29 76.99999999999997
R_0_14_28_2 Node0_14_28 Node0_15_28 76.99999999999984
R_0_14_28_3 Node0_14_28 Node1_14_28 3153.919999999994
I_0_14_29 GND Node0_14_29 4.081822999999993e-05A
R_0_14_29_1 Node0_14_29 Node0_14_30 76.99999999999997
R_0_14_29_2 Node0_14_29 Node0_15_29 77.00000000000011
R_0_14_29_3 Node0_14_29 Node1_14_29 3153.920000000006
I_0_14_30 GND Node0_14_30 4.081500000000008e-05A
R_0_14_30_1 Node0_14_30 Node0_14_31 76.99999999999984
R_0_14_30_2 Node0_14_30 Node0_15_30 76.99999999999984
R_0_14_30_3 Node0_14_30 Node1_14_30 3153.919999999994
I_0_14_31 GND Node0_14_31 4.081438000000008e-05A
R_0_14_31_2 Node0_14_31 Node0_15_31 76.99999999999984
R_0_14_31_3 Node0_14_31 Node1_14_31 3153.919999999994
I_0_15_0 GND Node0_15_0 4.0814280000000046e-05A
R_0_15_0_1 Node0_15_0 Node0_15_1 76.99999999999991
R_0_15_0_2 Node0_15_0 Node0_16_0 76.99999999999991
R_0_15_0_3 Node0_15_0 Node1_15_0 3153.9199999999973
I_0_15_1 GND Node0_15_1 4.081439000000005e-05A
R_0_15_1_1 Node0_15_1 Node0_15_2 76.99999999999991
R_0_15_1_2 Node0_15_1 Node0_16_1 76.99999999999991
R_0_15_1_3 Node0_15_1 Node1_15_1 3153.9199999999973
I_0_15_2 GND Node0_15_2 4.0815040000000045e-05A
R_0_15_2_1 Node0_15_2 Node0_15_3 76.99999999999991
R_0_15_2_2 Node0_15_2 Node0_16_2 76.99999999999991
R_0_15_2_3 Node0_15_2 Node1_15_2 3153.9199999999973
I_0_15_3 GND Node0_15_3 4.081849000000005e-05A
R_0_15_3_1 Node0_15_3 Node0_15_4 76.99999999999991
R_0_15_3_2 Node0_15_3 Node0_16_3 76.99999999999991
R_0_15_3_3 Node0_15_3 Node1_15_3 3153.9199999999973
I_0_15_4 GND Node0_15_4 4.0834410000000045e-05A
R_0_15_4_1 Node0_15_4 Node0_15_5 76.99999999999991
R_0_15_4_2 Node0_15_4 Node0_16_4 76.99999999999991
R_0_15_4_3 Node0_15_4 Node1_15_4 3153.9199999999973
I_0_15_5 GND Node0_15_5 4.089909000000005e-05A
R_0_15_5_1 Node0_15_5 Node0_15_6 76.99999999999991
R_0_15_5_2 Node0_15_5 Node0_16_5 76.99999999999991
R_0_15_5_3 Node0_15_5 Node1_15_5 3153.9199999999973
I_0_15_6 GND Node0_15_6 4.112942000000005e-05A
R_0_15_6_1 Node0_15_6 Node0_15_7 76.99999999999991
R_0_15_6_2 Node0_15_6 Node0_16_6 76.99999999999991
R_0_15_6_3 Node0_15_6 Node1_15_6 3153.9199999999973
I_0_15_7 GND Node0_15_7 4.1847630000000045e-05A
R_0_15_7_1 Node0_15_7 Node0_15_8 76.99999999999989
R_0_15_7_2 Node0_15_7 Node0_16_7 76.99999999999991
R_0_15_7_3 Node0_15_7 Node1_15_7 3153.9199999999973
I_0_15_8 GND Node0_15_8 4.3804420000000086e-05A
R_0_15_8_1 Node0_15_8 Node0_15_9 76.99999999999984
R_0_15_8_2 Node0_15_8 Node0_16_8 76.99999999999984
R_0_15_8_3 Node0_15_8 Node1_15_8 3153.919999999994
I_0_15_9 GND Node0_15_9 4.844990000000009e-05A
R_0_15_9_1 Node0_15_9 Node0_15_10 76.99999999999991
R_0_15_9_2 Node0_15_9 Node0_16_9 76.99999999999984
R_0_15_9_3 Node0_15_9 Node1_15_9 3153.919999999994
I_0_15_10 GND Node0_15_10 5.802143e-05A
R_0_15_10_1 Node0_15_10 Node0_15_11 76.99999999999991
R_0_15_10_2 Node0_15_10 Node0_16_10 77.0
R_0_15_10_3 Node0_15_10 Node1_15_10 3153.9200000000005
I_0_15_11 GND Node0_15_11 7.503480000000015e-05A
R_0_15_11_1 Node0_15_11 Node0_15_12 76.99999999999984
R_0_15_11_2 Node0_15_11 Node0_16_11 76.99999999999984
R_0_15_11_3 Node0_15_11 Node1_15_11 3153.919999999994
I_0_15_12 GND Node0_15_12 0.0001008732000000002A
R_0_15_12_1 Node0_15_12 Node0_15_13 76.99999999999984
R_0_15_12_2 Node0_15_12 Node0_16_12 76.99999999999984
R_0_15_12_3 Node0_15_12 Node1_15_12 3153.919999999994
I_0_15_13 GND Node0_15_13 0.00013383530000000027A
R_0_15_13_1 Node0_15_13 Node0_15_14 76.99999999999991
R_0_15_13_2 Node0_15_13 Node0_16_13 76.99999999999984
R_0_15_13_3 Node0_15_13 Node1_15_13 3153.919999999994
I_0_15_14 GND Node0_15_14 0.000167959A
R_0_15_14_1 Node0_15_14 Node0_15_15 76.99999999999991
R_0_15_14_2 Node0_15_14 Node0_16_14 77.0
R_0_15_14_3 Node0_15_14 Node1_15_14 3153.9200000000005
I_0_15_15 GND Node0_15_15 0.00019418010000000037A
R_0_15_15_1 Node0_15_15 Node0_15_16 76.99999999999984
R_0_15_15_2 Node0_15_15 Node0_16_15 76.99999999999984
R_0_15_15_3 Node0_15_15 Node1_15_15 3153.919999999994
I_0_15_16 GND Node0_15_16 0.0002040713000000004A
R_0_15_16_1 Node0_15_16 Node0_15_17 76.99999999999984
R_0_15_16_2 Node0_15_16 Node0_16_16 76.99999999999984
R_0_15_16_3 Node0_15_16 Node1_15_16 3153.919999999994
I_0_15_17 GND Node0_15_17 0.00019418010000000037A
R_0_15_17_1 Node0_15_17 Node0_15_18 76.99999999999984
R_0_15_17_2 Node0_15_17 Node0_16_17 76.99999999999984
R_0_15_17_3 Node0_15_17 Node1_15_17 3153.919999999994
I_0_15_18 GND Node0_15_18 0.00016795900000000032A
R_0_15_18_1 Node0_15_18 Node0_15_19 76.99999999999984
R_0_15_18_2 Node0_15_18 Node0_16_18 76.99999999999984
R_0_15_18_3 Node0_15_18 Node1_15_18 3153.919999999994
I_0_15_19 GND Node0_15_19 0.00013383530000000027A
R_0_15_19_1 Node0_15_19 Node0_15_20 76.99999999999984
R_0_15_19_2 Node0_15_19 Node0_16_19 76.99999999999984
R_0_15_19_3 Node0_15_19 Node1_15_19 3153.919999999994
I_0_15_20 GND Node0_15_20 0.0001008732000000002A
R_0_15_20_1 Node0_15_20 Node0_15_21 76.99999999999997
R_0_15_20_2 Node0_15_20 Node0_16_20 76.99999999999984
R_0_15_20_3 Node0_15_20 Node1_15_20 3153.919999999994
I_0_15_21 GND Node0_15_21 7.503479999999988e-05A
R_0_15_21_1 Node0_15_21 Node0_15_22 76.99999999999997
R_0_15_21_2 Node0_15_21 Node0_16_21 77.00000000000011
R_0_15_21_3 Node0_15_21 Node1_15_21 3153.920000000006
I_0_15_22 GND Node0_15_22 5.802143000000012e-05A
R_0_15_22_1 Node0_15_22 Node0_15_23 76.99999999999984
R_0_15_22_2 Node0_15_22 Node0_16_22 76.99999999999984
R_0_15_22_3 Node0_15_22 Node1_15_22 3153.919999999994
I_0_15_23 GND Node0_15_23 4.844990000000009e-05A
R_0_15_23_1 Node0_15_23 Node0_15_24 76.99999999999984
R_0_15_23_2 Node0_15_23 Node0_16_23 76.99999999999984
R_0_15_23_3 Node0_15_23 Node1_15_23 3153.919999999994
I_0_15_24 GND Node0_15_24 4.3804420000000086e-05A
R_0_15_24_1 Node0_15_24 Node0_15_25 76.99999999999984
R_0_15_24_2 Node0_15_24 Node0_16_24 76.99999999999984
R_0_15_24_3 Node0_15_24 Node1_15_24 3153.919999999994
I_0_15_25 GND Node0_15_25 4.184763000000008e-05A
R_0_15_25_1 Node0_15_25 Node0_15_26 76.99999999999984
R_0_15_25_2 Node0_15_25 Node0_16_25 76.99999999999984
R_0_15_25_3 Node0_15_25 Node1_15_25 3153.919999999994
I_0_15_26 GND Node0_15_26 4.112942000000008e-05A
R_0_15_26_1 Node0_15_26 Node0_15_27 76.99999999999984
R_0_15_26_2 Node0_15_26 Node0_16_26 76.99999999999984
R_0_15_26_3 Node0_15_26 Node1_15_26 3153.919999999994
I_0_15_27 GND Node0_15_27 4.0899090000000083e-05A
R_0_15_27_1 Node0_15_27 Node0_15_28 76.99999999999984
R_0_15_27_2 Node0_15_27 Node0_16_27 76.99999999999984
R_0_15_27_3 Node0_15_27 Node1_15_27 3153.919999999994
I_0_15_28 GND Node0_15_28 4.083441000000008e-05A
R_0_15_28_1 Node0_15_28 Node0_15_29 76.99999999999997
R_0_15_28_2 Node0_15_28 Node0_16_28 76.99999999999984
R_0_15_28_3 Node0_15_28 Node1_15_28 3153.919999999994
I_0_15_29 GND Node0_15_29 4.0818489999999934e-05A
R_0_15_29_1 Node0_15_29 Node0_15_30 76.99999999999997
R_0_15_29_2 Node0_15_29 Node0_16_29 77.00000000000011
R_0_15_29_3 Node0_15_29 Node1_15_29 3153.920000000006
I_0_15_30 GND Node0_15_30 4.081504000000008e-05A
R_0_15_30_1 Node0_15_30 Node0_15_31 76.99999999999984
R_0_15_30_2 Node0_15_30 Node0_16_30 76.99999999999984
R_0_15_30_3 Node0_15_30 Node1_15_30 3153.919999999994
I_0_15_31 GND Node0_15_31 4.081439000000008e-05A
R_0_15_31_2 Node0_15_31 Node0_16_31 76.99999999999984
R_0_15_31_3 Node0_15_31 Node1_15_31 3153.919999999994
I_0_16_0 GND Node0_16_0 4.0814280000000046e-05A
R_0_16_0_1 Node0_16_0 Node0_16_1 76.99999999999991
R_0_16_0_2 Node0_16_0 Node0_17_0 77.0
R_0_16_0_3 Node0_16_0 Node1_16_0 3153.9199999999973
I_0_16_1 GND Node0_16_1 4.0814380000000046e-05A
R_0_16_1_1 Node0_16_1 Node0_16_2 76.99999999999991
R_0_16_1_2 Node0_16_1 Node0_17_1 77.0
R_0_16_1_3 Node0_16_1 Node1_16_1 3153.9199999999973
I_0_16_2 GND Node0_16_2 4.081500000000005e-05A
R_0_16_2_1 Node0_16_2 Node0_16_3 76.99999999999991
R_0_16_2_2 Node0_16_2 Node0_17_2 77.0
R_0_16_2_3 Node0_16_2 Node1_16_2 3153.9199999999973
I_0_16_3 GND Node0_16_3 4.0818230000000044e-05A
R_0_16_3_1 Node0_16_3 Node0_16_4 76.99999999999991
R_0_16_3_2 Node0_16_3 Node0_17_3 77.0
R_0_16_3_3 Node0_16_3 Node1_16_3 3153.9199999999973
I_0_16_4 GND Node0_16_4 4.083319000000005e-05A
R_0_16_4_1 Node0_16_4 Node0_16_5 76.99999999999991
R_0_16_4_2 Node0_16_4 Node0_17_4 77.0
R_0_16_4_3 Node0_16_4 Node1_16_4 3153.9199999999973
I_0_16_5 GND Node0_16_5 4.089395000000005e-05A
R_0_16_5_1 Node0_16_5 Node0_16_6 76.99999999999991
R_0_16_5_2 Node0_16_5 Node0_17_5 77.0
R_0_16_5_3 Node0_16_5 Node1_16_5 3153.9199999999973
I_0_16_6 GND Node0_16_6 4.111033000000005e-05A
R_0_16_6_1 Node0_16_6 Node0_16_7 76.99999999999991
R_0_16_6_2 Node0_16_6 Node0_17_6 77.0
R_0_16_6_3 Node0_16_6 Node1_16_6 3153.9199999999973
I_0_16_7 GND Node0_16_7 4.178503000000005e-05A
R_0_16_7_1 Node0_16_7 Node0_16_8 76.99999999999989
R_0_16_7_2 Node0_16_7 Node0_17_7 77.0
R_0_16_7_3 Node0_16_7 Node1_16_7 3153.9199999999973
I_0_16_8 GND Node0_16_8 4.3623260000000085e-05A
R_0_16_8_1 Node0_16_8 Node0_16_9 76.99999999999984
R_0_16_8_2 Node0_16_8 Node0_17_8 76.99999999999991
R_0_16_8_3 Node0_16_8 Node1_16_8 3153.919999999994
I_0_16_9 GND Node0_16_9 4.7987280000000094e-05A
R_0_16_9_1 Node0_16_9 Node0_16_10 76.99999999999991
R_0_16_9_2 Node0_16_9 Node0_17_9 76.99999999999991
R_0_16_9_3 Node0_16_9 Node1_16_9 3153.919999999994
I_0_16_10 GND Node0_16_10 5.69789e-05A
R_0_16_10_1 Node0_16_10 Node0_16_11 76.99999999999991
R_0_16_10_2 Node0_16_10 Node0_17_10 77.00000000000006
R_0_16_10_3 Node0_16_10 Node1_16_10 3153.9200000000005
I_0_16_11 GND Node0_16_11 7.296148000000015e-05A
R_0_16_11_1 Node0_16_11 Node0_16_12 76.99999999999984
R_0_16_11_2 Node0_16_11 Node0_17_11 76.99999999999991
R_0_16_11_3 Node0_16_11 Node1_16_11 3153.919999999994
I_0_16_12 GND Node0_16_12 9.723439000000019e-05A
R_0_16_12_1 Node0_16_12 Node0_16_13 76.99999999999984
R_0_16_12_2 Node0_16_12 Node0_17_12 76.99999999999991
R_0_16_12_3 Node0_16_12 Node1_16_12 3153.919999999994
I_0_16_13 GND Node0_16_13 0.00012819950000000024A
R_0_16_13_1 Node0_16_13 Node0_16_14 76.99999999999991
R_0_16_13_2 Node0_16_13 Node0_17_13 76.99999999999991
R_0_16_13_3 Node0_16_13 Node1_16_13 3153.919999999994
I_0_16_14 GND Node0_16_14 0.0001602557A
R_0_16_14_1 Node0_16_14 Node0_16_15 76.99999999999991
R_0_16_14_2 Node0_16_14 Node0_17_14 77.00000000000006
R_0_16_14_3 Node0_16_14 Node1_16_14 3153.9200000000005
I_0_16_15 GND Node0_16_15 0.00018488810000000038A
R_0_16_15_1 Node0_16_15 Node0_16_16 76.99999999999984
R_0_16_15_2 Node0_16_15 Node0_17_15 76.99999999999991
R_0_16_15_3 Node0_16_15 Node1_16_15 3153.919999999994
I_0_16_16 GND Node0_16_16 0.00019418010000000037A
R_0_16_16_1 Node0_16_16 Node0_16_17 76.99999999999984
R_0_16_16_2 Node0_16_16 Node0_17_16 76.99999999999991
R_0_16_16_3 Node0_16_16 Node1_16_16 3153.919999999994
I_0_16_17 GND Node0_16_17 0.00018488810000000038A
R_0_16_17_1 Node0_16_17 Node0_16_18 76.99999999999984
R_0_16_17_2 Node0_16_17 Node0_17_17 76.99999999999991
R_0_16_17_3 Node0_16_17 Node1_16_17 3153.919999999994
I_0_16_18 GND Node0_16_18 0.00016025570000000034A
R_0_16_18_1 Node0_16_18 Node0_16_19 76.99999999999984
R_0_16_18_2 Node0_16_18 Node0_17_18 76.99999999999991
R_0_16_18_3 Node0_16_18 Node1_16_18 3153.919999999994
I_0_16_19 GND Node0_16_19 0.00012819950000000024A
R_0_16_19_1 Node0_16_19 Node0_16_20 76.99999999999984
R_0_16_19_2 Node0_16_19 Node0_17_19 76.99999999999991
R_0_16_19_3 Node0_16_19 Node1_16_19 3153.919999999994
I_0_16_20 GND Node0_16_20 9.723439000000019e-05A
R_0_16_20_1 Node0_16_20 Node0_16_21 76.99999999999997
R_0_16_20_2 Node0_16_20 Node0_17_20 76.99999999999991
R_0_16_20_3 Node0_16_20 Node1_16_20 3153.919999999994
I_0_16_21 GND Node0_16_21 7.296147999999988e-05A
R_0_16_21_1 Node0_16_21 Node0_16_22 76.99999999999997
R_0_16_21_2 Node0_16_21 Node0_17_21 77.00000000000018
R_0_16_21_3 Node0_16_21 Node1_16_21 3153.920000000006
I_0_16_22 GND Node0_16_22 5.697890000000011e-05A
R_0_16_22_1 Node0_16_22 Node0_16_23 76.99999999999984
R_0_16_22_2 Node0_16_22 Node0_17_22 76.99999999999991
R_0_16_22_3 Node0_16_22 Node1_16_22 3153.919999999994
I_0_16_23 GND Node0_16_23 4.7987280000000094e-05A
R_0_16_23_1 Node0_16_23 Node0_16_24 76.99999999999984
R_0_16_23_2 Node0_16_23 Node0_17_23 76.99999999999991
R_0_16_23_3 Node0_16_23 Node1_16_23 3153.919999999994
I_0_16_24 GND Node0_16_24 4.3623260000000085e-05A
R_0_16_24_1 Node0_16_24 Node0_16_25 76.99999999999984
R_0_16_24_2 Node0_16_24 Node0_17_24 76.99999999999991
R_0_16_24_3 Node0_16_24 Node1_16_24 3153.919999999994
I_0_16_25 GND Node0_16_25 4.1785030000000084e-05A
R_0_16_25_1 Node0_16_25 Node0_16_26 76.99999999999984
R_0_16_25_2 Node0_16_25 Node0_17_25 76.99999999999991
R_0_16_25_3 Node0_16_25 Node1_16_25 3153.919999999994
I_0_16_26 GND Node0_16_26 4.111033000000008e-05A
R_0_16_26_1 Node0_16_26 Node0_16_27 76.99999999999984
R_0_16_26_2 Node0_16_26 Node0_17_26 76.99999999999991
R_0_16_26_3 Node0_16_26 Node1_16_26 3153.919999999994
I_0_16_27 GND Node0_16_27 4.089395000000008e-05A
R_0_16_27_1 Node0_16_27 Node0_16_28 76.99999999999984
R_0_16_27_2 Node0_16_27 Node0_17_27 76.99999999999991
R_0_16_27_3 Node0_16_27 Node1_16_27 3153.919999999994
I_0_16_28 GND Node0_16_28 4.083319000000008e-05A
R_0_16_28_1 Node0_16_28 Node0_16_29 76.99999999999997
R_0_16_28_2 Node0_16_28 Node0_17_28 76.99999999999991
R_0_16_28_3 Node0_16_28 Node1_16_28 3153.919999999994
I_0_16_29 GND Node0_16_29 4.081822999999993e-05A
R_0_16_29_1 Node0_16_29 Node0_16_30 76.99999999999997
R_0_16_29_2 Node0_16_29 Node0_17_29 77.00000000000018
R_0_16_29_3 Node0_16_29 Node1_16_29 3153.920000000006
I_0_16_30 GND Node0_16_30 4.081500000000008e-05A
R_0_16_30_1 Node0_16_30 Node0_16_31 76.99999999999984
R_0_16_30_2 Node0_16_30 Node0_17_30 76.99999999999991
R_0_16_30_3 Node0_16_30 Node1_16_30 3153.919999999994
I_0_16_31 GND Node0_16_31 4.081438000000008e-05A
R_0_16_31_2 Node0_16_31 Node0_17_31 76.99999999999991
R_0_16_31_3 Node0_16_31 Node1_16_31 3153.919999999994
I_0_17_0 GND Node0_17_0 4.0814279999999965e-05A
R_0_17_0_1 Node0_17_0 Node0_17_1 77.00000000000007
R_0_17_0_2 Node0_17_0 Node0_18_0 77.0
R_0_17_0_3 Node0_17_0 Node1_17_0 3153.9200000000033
I_0_17_1 GND Node0_17_1 4.0814359999999963e-05A
R_0_17_1_1 Node0_17_1 Node0_17_2 77.00000000000007
R_0_17_1_2 Node0_17_1 Node0_18_1 77.0
R_0_17_1_3 Node0_17_1 Node1_17_1 3153.9200000000033
I_0_17_2 GND Node0_17_2 4.0814869999999965e-05A
R_0_17_2_1 Node0_17_2 Node0_17_3 77.00000000000007
R_0_17_2_2 Node0_17_2 Node0_18_2 77.0
R_0_17_2_3 Node0_17_2 Node1_17_2 3153.9200000000033
I_0_17_3 GND Node0_17_3 4.081754999999996e-05A
R_0_17_3_1 Node0_17_3 Node0_17_4 77.00000000000007
R_0_17_3_2 Node0_17_3 Node0_18_3 77.0
R_0_17_3_3 Node0_17_3 Node1_17_3 3153.9200000000033
I_0_17_4 GND Node0_17_4 4.082994999999996e-05A
R_0_17_4_1 Node0_17_4 Node0_17_5 77.00000000000007
R_0_17_4_2 Node0_17_4 Node0_18_4 77.0
R_0_17_4_3 Node0_17_4 Node1_17_4 3153.9200000000033
I_0_17_5 GND Node0_17_5 4.088031999999996e-05A
R_0_17_5_1 Node0_17_5 Node0_17_6 77.00000000000007
R_0_17_5_2 Node0_17_5 Node0_18_5 77.0
R_0_17_5_3 Node0_17_5 Node1_17_5 3153.9200000000033
I_0_17_6 GND Node0_17_6 4.105970999999997e-05A
R_0_17_6_1 Node0_17_6 Node0_17_7 77.00000000000007
R_0_17_6_2 Node0_17_6 Node0_18_6 77.0
R_0_17_6_3 Node0_17_6 Node1_17_6 3153.9200000000033
I_0_17_7 GND Node0_17_7 4.1619049999999965e-05A
R_0_17_7_1 Node0_17_7 Node0_17_8 77.00000000000003
R_0_17_7_2 Node0_17_7 Node0_18_7 77.0
R_0_17_7_3 Node0_17_7 Node1_17_7 3153.9200000000033
I_0_17_8 GND Node0_17_8 4.3143e-05A
R_0_17_8_1 Node0_17_8 Node0_17_9 77.0
R_0_17_8_2 Node0_17_8 Node0_18_8 76.99999999999991
R_0_17_8_3 Node0_17_8 Node1_17_8 3153.9200000000005
I_0_17_9 GND Node0_17_9 4.67609e-05A
R_0_17_9_1 Node0_17_9 Node0_17_10 77.00000000000006
R_0_17_9_2 Node0_17_9 Node0_18_9 76.99999999999991
R_0_17_9_3 Node0_17_9 Node1_17_9 3153.9200000000005
I_0_17_10 GND Node0_17_10 5.421521999999991e-05A
R_0_17_10_1 Node0_17_10 Node0_17_11 77.00000000000006
R_0_17_10_2 Node0_17_10 Node0_18_10 77.00000000000006
R_0_17_10_3 Node0_17_10 Node1_17_10 3153.920000000006
I_0_17_11 GND Node0_17_11 6.746524e-05A
R_0_17_11_1 Node0_17_11 Node0_17_12 77.0
R_0_17_11_2 Node0_17_11 Node0_18_11 76.99999999999991
R_0_17_11_3 Node0_17_11 Node1_17_11 3153.9200000000005
I_0_17_12 GND Node0_17_12 8.758819e-05A
R_0_17_12_1 Node0_17_12 Node0_17_13 77.0
R_0_17_12_2 Node0_17_12 Node0_18_12 76.99999999999991
R_0_17_12_3 Node0_17_12 Node1_17_12 3153.9200000000005
I_0_17_13 GND Node0_17_13 0.0001132591A
R_0_17_13_1 Node0_17_13 Node0_17_14 77.00000000000006
R_0_17_13_2 Node0_17_13 Node0_18_13 76.99999999999991
R_0_17_13_3 Node0_17_13 Node1_17_13 3153.9200000000005
I_0_17_14 GND Node0_17_14 0.00013983469999999975A
R_0_17_14_1 Node0_17_14 Node0_17_15 77.00000000000006
R_0_17_14_2 Node0_17_14 Node0_18_14 77.00000000000006
R_0_17_14_3 Node0_17_14 Node1_17_14 3153.920000000006
I_0_17_15 GND Node0_17_15 0.0001602557A
R_0_17_15_1 Node0_17_15 Node0_17_16 77.0
R_0_17_15_2 Node0_17_15 Node0_18_15 76.99999999999991
R_0_17_15_3 Node0_17_15 Node1_17_15 3153.9200000000005
I_0_17_16 GND Node0_17_16 0.000167959A
R_0_17_16_1 Node0_17_16 Node0_17_17 77.0
R_0_17_16_2 Node0_17_16 Node0_18_16 76.99999999999991
R_0_17_16_3 Node0_17_16 Node1_17_16 3153.9200000000005
I_0_17_17 GND Node0_17_17 0.0001602557A
R_0_17_17_1 Node0_17_17 Node0_17_18 77.0
R_0_17_17_2 Node0_17_17 Node0_18_17 76.99999999999991
R_0_17_17_3 Node0_17_17 Node1_17_17 3153.9200000000005
I_0_17_18 GND Node0_17_18 0.0001398347A
R_0_17_18_1 Node0_17_18 Node0_17_19 77.0
R_0_17_18_2 Node0_17_18 Node0_18_18 76.99999999999991
R_0_17_18_3 Node0_17_18 Node1_17_18 3153.9200000000005
I_0_17_19 GND Node0_17_19 0.0001132591A
R_0_17_19_1 Node0_17_19 Node0_17_20 77.0
R_0_17_19_2 Node0_17_19 Node0_18_19 76.99999999999991
R_0_17_19_3 Node0_17_19 Node1_17_19 3153.9200000000005
I_0_17_20 GND Node0_17_20 8.758819e-05A
R_0_17_20_1 Node0_17_20 Node0_17_21 77.00000000000013
R_0_17_20_2 Node0_17_20 Node0_18_20 76.99999999999991
R_0_17_20_3 Node0_17_20 Node1_17_20 3153.9200000000005
I_0_17_21 GND Node0_17_21 6.746523999999976e-05A
R_0_17_21_1 Node0_17_21 Node0_17_22 77.00000000000013
R_0_17_21_2 Node0_17_21 Node0_18_21 77.00000000000018
R_0_17_21_3 Node0_17_21 Node1_17_21 3153.920000000011
I_0_17_22 GND Node0_17_22 5.421522e-05A
R_0_17_22_1 Node0_17_22 Node0_17_23 77.0
R_0_17_22_2 Node0_17_22 Node0_18_22 76.99999999999991
R_0_17_22_3 Node0_17_22 Node1_17_22 3153.9200000000005
I_0_17_23 GND Node0_17_23 4.67609e-05A
R_0_17_23_1 Node0_17_23 Node0_17_24 77.0
R_0_17_23_2 Node0_17_23 Node0_18_23 76.99999999999991
R_0_17_23_3 Node0_17_23 Node1_17_23 3153.9200000000005
I_0_17_24 GND Node0_17_24 4.3143e-05A
R_0_17_24_1 Node0_17_24 Node0_17_25 77.0
R_0_17_24_2 Node0_17_24 Node0_18_24 76.99999999999991
R_0_17_24_3 Node0_17_24 Node1_17_24 3153.9200000000005
I_0_17_25 GND Node0_17_25 4.161905e-05A
R_0_17_25_1 Node0_17_25 Node0_17_26 77.0
R_0_17_25_2 Node0_17_25 Node0_18_25 76.99999999999991
R_0_17_25_3 Node0_17_25 Node1_17_25 3153.9200000000005
I_0_17_26 GND Node0_17_26 4.105971e-05A
R_0_17_26_1 Node0_17_26 Node0_17_27 77.0
R_0_17_26_2 Node0_17_26 Node0_18_26 76.99999999999991
R_0_17_26_3 Node0_17_26 Node1_17_26 3153.9200000000005
I_0_17_27 GND Node0_17_27 4.088032e-05A
R_0_17_27_1 Node0_17_27 Node0_17_28 77.0
R_0_17_27_2 Node0_17_27 Node0_18_27 76.99999999999991
R_0_17_27_3 Node0_17_27 Node1_17_27 3153.9200000000005
I_0_17_28 GND Node0_17_28 4.082995e-05A
R_0_17_28_1 Node0_17_28 Node0_17_29 77.00000000000013
R_0_17_28_2 Node0_17_28 Node0_18_28 76.99999999999991
R_0_17_28_3 Node0_17_28 Node1_17_28 3153.9200000000005
I_0_17_29 GND Node0_17_29 4.081754999999986e-05A
R_0_17_29_1 Node0_17_29 Node0_17_30 77.00000000000013
R_0_17_29_2 Node0_17_29 Node0_18_29 77.00000000000018
R_0_17_29_3 Node0_17_29 Node1_17_29 3153.920000000011
I_0_17_30 GND Node0_17_30 4.081487e-05A
R_0_17_30_1 Node0_17_30 Node0_17_31 77.0
R_0_17_30_2 Node0_17_30 Node0_18_30 76.99999999999991
R_0_17_30_3 Node0_17_30 Node1_17_30 3153.9200000000005
I_0_17_31 GND Node0_17_31 4.081436e-05A
R_0_17_31_2 Node0_17_31 Node0_18_31 76.99999999999991
R_0_17_31_3 Node0_17_31 Node1_17_31 3153.9200000000005
I_0_18_0 GND Node0_18_0 4.0814270000000045e-05A
R_0_18_0_1 Node0_18_0 Node0_18_1 76.99999999999991
R_0_18_0_2 Node0_18_0 Node0_19_0 76.99999999999991
R_0_18_0_3 Node0_18_0 Node1_18_0 3153.9199999999973
I_0_18_1 GND Node0_18_1 4.081434000000005e-05A
R_0_18_1_1 Node0_18_1 Node0_18_2 76.99999999999991
R_0_18_1_2 Node0_18_1 Node0_19_1 76.99999999999991
R_0_18_1_3 Node0_18_1 Node1_18_1 3153.9199999999973
I_0_18_2 GND Node0_18_2 4.081471000000005e-05A
R_0_18_2_1 Node0_18_2 Node0_18_3 76.99999999999991
R_0_18_2_2 Node0_18_2 Node0_19_2 76.99999999999991
R_0_18_2_3 Node0_18_2 Node1_18_2 3153.9199999999973
I_0_18_3 GND Node0_18_3 4.081667000000005e-05A
R_0_18_3_1 Node0_18_3 Node0_18_4 76.99999999999991
R_0_18_3_2 Node0_18_3 Node0_19_3 76.99999999999991
R_0_18_3_3 Node0_18_3 Node1_18_3 3153.9199999999973
I_0_18_4 GND Node0_18_4 4.082574000000005e-05A
R_0_18_4_1 Node0_18_4 Node0_18_5 76.99999999999991
R_0_18_4_2 Node0_18_4 Node0_19_4 76.99999999999991
R_0_18_4_3 Node0_18_4 Node1_18_4 3153.9199999999973
I_0_18_5 GND Node0_18_5 4.0862590000000044e-05A
R_0_18_5_1 Node0_18_5 Node0_18_6 76.99999999999991
R_0_18_5_2 Node0_18_5 Node0_19_5 76.99999999999991
R_0_18_5_3 Node0_18_5 Node1_18_5 3153.9199999999973
I_0_18_6 GND Node0_18_6 4.099384000000005e-05A
R_0_18_6_1 Node0_18_6 Node0_18_7 76.99999999999991
R_0_18_6_2 Node0_18_6 Node0_19_6 76.99999999999991
R_0_18_6_3 Node0_18_6 Node1_18_6 3153.9199999999973
I_0_18_7 GND Node0_18_7 4.140306000000005e-05A
R_0_18_7_1 Node0_18_7 Node0_18_8 76.99999999999989
R_0_18_7_2 Node0_18_7 Node0_19_7 76.99999999999991
R_0_18_7_3 Node0_18_7 Node1_18_7 3153.9199999999973
I_0_18_8 GND Node0_18_8 4.251800000000009e-05A
R_0_18_8_1 Node0_18_8 Node0_18_9 76.99999999999984
R_0_18_8_2 Node0_18_8 Node0_19_8 76.99999999999984
R_0_18_8_3 Node0_18_8 Node1_18_8 3153.919999999994
I_0_18_9 GND Node0_18_9 4.516492000000009e-05A
R_0_18_9_1 Node0_18_9 Node0_18_10 76.99999999999991
R_0_18_9_2 Node0_18_9 Node0_19_9 76.99999999999984
R_0_18_9_3 Node0_18_9 Node1_18_9 3153.919999999994
I_0_18_10 GND Node0_18_10 5.061861e-05A
R_0_18_10_1 Node0_18_10 Node0_18_11 76.99999999999991
R_0_18_10_2 Node0_18_10 Node0_19_10 77.0
R_0_18_10_3 Node0_18_10 Node1_18_10 3153.9200000000005
I_0_18_11 GND Node0_18_11 6.031254000000012e-05A
R_0_18_11_1 Node0_18_11 Node0_18_12 76.99999999999984
R_0_18_11_2 Node0_18_11 Node0_19_11 76.99999999999984
R_0_18_11_3 Node0_18_11 Node1_18_11 3153.919999999994
I_0_18_12 GND Node0_18_12 7.503480000000015e-05A
R_0_18_12_1 Node0_18_12 Node0_18_13 76.99999999999984
R_0_18_12_2 Node0_18_12 Node0_19_12 76.99999999999984
R_0_18_12_3 Node0_18_12 Node1_18_12 3153.919999999994
I_0_18_13 GND Node0_18_13 9.381607000000019e-05A
R_0_18_13_1 Node0_18_13 Node0_18_14 76.99999999999991
R_0_18_13_2 Node0_18_13 Node0_19_13 76.99999999999984
R_0_18_13_3 Node0_18_13 Node1_18_13 3153.919999999994
I_0_18_14 GND Node0_18_14 0.0001132591A
R_0_18_14_1 Node0_18_14 Node0_18_15 76.99999999999991
R_0_18_14_2 Node0_18_14 Node0_19_14 77.0
R_0_18_14_3 Node0_18_14 Node1_18_14 3153.9200000000005
I_0_18_15 GND Node0_18_15 0.00012819950000000024A
R_0_18_15_1 Node0_18_15 Node0_18_16 76.99999999999984
R_0_18_15_2 Node0_18_15 Node0_19_15 76.99999999999984
R_0_18_15_3 Node0_18_15 Node1_18_15 3153.919999999994
I_0_18_16 GND Node0_18_16 0.00013383530000000027A
R_0_18_16_1 Node0_18_16 Node0_18_17 76.99999999999984
R_0_18_16_2 Node0_18_16 Node0_19_16 76.99999999999984
R_0_18_16_3 Node0_18_16 Node1_18_16 3153.919999999994
I_0_18_17 GND Node0_18_17 0.00012819950000000024A
R_0_18_17_1 Node0_18_17 Node0_18_18 76.99999999999984
R_0_18_17_2 Node0_18_17 Node0_19_17 76.99999999999984
R_0_18_17_3 Node0_18_17 Node1_18_17 3153.919999999994
I_0_18_18 GND Node0_18_18 0.00011325910000000023A
R_0_18_18_1 Node0_18_18 Node0_18_19 76.99999999999984
R_0_18_18_2 Node0_18_18 Node0_19_18 76.99999999999984
R_0_18_18_3 Node0_18_18 Node1_18_18 3153.919999999994
I_0_18_19 GND Node0_18_19 9.381607000000019e-05A
R_0_18_19_1 Node0_18_19 Node0_18_20 76.99999999999984
R_0_18_19_2 Node0_18_19 Node0_19_19 76.99999999999984
R_0_18_19_3 Node0_18_19 Node1_18_19 3153.919999999994
I_0_18_20 GND Node0_18_20 7.503480000000015e-05A
R_0_18_20_1 Node0_18_20 Node0_18_21 76.99999999999997
R_0_18_20_2 Node0_18_20 Node0_19_20 76.99999999999984
R_0_18_20_3 Node0_18_20 Node1_18_20 3153.919999999994
I_0_18_21 GND Node0_18_21 6.03125399999999e-05A
R_0_18_21_1 Node0_18_21 Node0_18_22 76.99999999999997
R_0_18_21_2 Node0_18_21 Node0_19_21 77.00000000000011
R_0_18_21_3 Node0_18_21 Node1_18_21 3153.920000000006
I_0_18_22 GND Node0_18_22 5.06186100000001e-05A
R_0_18_22_1 Node0_18_22 Node0_18_23 76.99999999999984
R_0_18_22_2 Node0_18_22 Node0_19_22 76.99999999999984
R_0_18_22_3 Node0_18_22 Node1_18_22 3153.919999999994
I_0_18_23 GND Node0_18_23 4.516492000000009e-05A
R_0_18_23_1 Node0_18_23 Node0_18_24 76.99999999999984
R_0_18_23_2 Node0_18_23 Node0_19_23 76.99999999999984
R_0_18_23_3 Node0_18_23 Node1_18_23 3153.919999999994
I_0_18_24 GND Node0_18_24 4.251800000000009e-05A
R_0_18_24_1 Node0_18_24 Node0_18_25 76.99999999999984
R_0_18_24_2 Node0_18_24 Node0_19_24 76.99999999999984
R_0_18_24_3 Node0_18_24 Node1_18_24 3153.919999999994
I_0_18_25 GND Node0_18_25 4.140306000000008e-05A
R_0_18_25_1 Node0_18_25 Node0_18_26 76.99999999999984
R_0_18_25_2 Node0_18_25 Node0_19_25 76.99999999999984
R_0_18_25_3 Node0_18_25 Node1_18_25 3153.919999999994
I_0_18_26 GND Node0_18_26 4.0993840000000085e-05A
R_0_18_26_1 Node0_18_26 Node0_18_27 76.99999999999984
R_0_18_26_2 Node0_18_26 Node0_19_26 76.99999999999984
R_0_18_26_3 Node0_18_26 Node1_18_26 3153.919999999994
I_0_18_27 GND Node0_18_27 4.086259000000008e-05A
R_0_18_27_1 Node0_18_27 Node0_18_28 76.99999999999984
R_0_18_27_2 Node0_18_27 Node0_19_27 76.99999999999984
R_0_18_27_3 Node0_18_27 Node1_18_27 3153.919999999994
I_0_18_28 GND Node0_18_28 4.082574000000008e-05A
R_0_18_28_1 Node0_18_28 Node0_18_29 76.99999999999997
R_0_18_28_2 Node0_18_28 Node0_19_28 76.99999999999984
R_0_18_28_3 Node0_18_28 Node1_18_28 3153.919999999994
I_0_18_29 GND Node0_18_29 4.0816669999999935e-05A
R_0_18_29_1 Node0_18_29 Node0_18_30 76.99999999999997
R_0_18_29_2 Node0_18_29 Node0_19_29 77.00000000000011
R_0_18_29_3 Node0_18_29 Node1_18_29 3153.920000000006
I_0_18_30 GND Node0_18_30 4.081471000000008e-05A
R_0_18_30_1 Node0_18_30 Node0_18_31 76.99999999999984
R_0_18_30_2 Node0_18_30 Node0_19_30 76.99999999999984
R_0_18_30_3 Node0_18_30 Node1_18_30 3153.919999999994
I_0_18_31 GND Node0_18_31 4.0814340000000084e-05A
R_0_18_31_2 Node0_18_31 Node0_19_31 76.99999999999984
R_0_18_31_3 Node0_18_31 Node1_18_31 3153.919999999994
I_0_19_0 GND Node0_19_0 4.0814270000000045e-05A
R_0_19_0_1 Node0_19_0 Node0_19_1 76.99999999999991
R_0_19_0_2 Node0_19_0 Node0_20_0 76.99999999999991
R_0_19_0_3 Node0_19_0 Node1_19_0 3153.9199999999973
I_0_19_1 GND Node0_19_1 4.081431000000004e-05A
R_0_19_1_1 Node0_19_1 Node0_19_2 76.99999999999991
R_0_19_1_2 Node0_19_1 Node0_20_1 76.99999999999991
R_0_19_1_3 Node0_19_1 Node1_19_1 3153.9199999999973
I_0_19_2 GND Node0_19_2 4.0814550000000044e-05A
R_0_19_2_1 Node0_19_2 Node0_19_3 76.99999999999991
R_0_19_2_2 Node0_19_2 Node0_20_2 76.99999999999991
R_0_19_2_3 Node0_19_2 Node1_19_2 3153.9199999999973
I_0_19_3 GND Node0_19_3 4.0815820000000045e-05A
R_0_19_3_1 Node0_19_3 Node0_19_4 76.99999999999991
R_0_19_3_2 Node0_19_3 Node0_20_3 76.99999999999991
R_0_19_3_3 Node0_19_3 Node1_19_3 3153.9199999999973
I_0_19_4 GND Node0_19_4 4.082168000000005e-05A
R_0_19_4_1 Node0_19_4 Node0_19_5 76.99999999999991
R_0_19_4_2 Node0_19_4 Node0_20_4 76.99999999999991
R_0_19_4_3 Node0_19_4 Node1_19_4 3153.9199999999973
I_0_19_5 GND Node0_19_5 4.0845470000000046e-05A
R_0_19_5_1 Node0_19_5 Node0_19_6 76.99999999999991
R_0_19_5_2 Node0_19_5 Node0_20_5 76.99999999999991
R_0_19_5_3 Node0_19_5 Node1_19_5 3153.9199999999973
I_0_19_6 GND Node0_19_6 4.093020000000005e-05A
R_0_19_6_1 Node0_19_6 Node0_19_7 76.99999999999991
R_0_19_6_2 Node0_19_6 Node0_20_6 76.99999999999991
R_0_19_6_3 Node0_19_6 Node1_19_6 3153.9199999999973
I_0_19_7 GND Node0_19_7 4.119442000000005e-05A
R_0_19_7_1 Node0_19_7 Node0_19_8 76.99999999999989
R_0_19_7_2 Node0_19_7 Node0_20_7 76.99999999999991
R_0_19_7_3 Node0_19_7 Node1_19_7 3153.9199999999973
I_0_19_8 GND Node0_19_8 4.191428000000008e-05A
R_0_19_8_1 Node0_19_8 Node0_19_9 76.99999999999984
R_0_19_8_2 Node0_19_8 Node0_20_8 76.99999999999984
R_0_19_8_3 Node0_19_8 Node1_19_8 3153.919999999994
I_0_19_9 GND Node0_19_9 4.3623260000000085e-05A
R_0_19_9_1 Node0_19_9 Node0_19_10 76.99999999999991
R_0_19_9_2 Node0_19_9 Node0_20_9 76.99999999999984
R_0_19_9_3 Node0_19_9 Node1_19_9 3153.919999999994
I_0_19_10 GND Node0_19_10 4.714443e-05A
R_0_19_10_1 Node0_19_10 Node0_19_11 76.99999999999991
R_0_19_10_2 Node0_19_10 Node0_20_10 77.0
R_0_19_10_3 Node0_19_10 Node1_19_10 3153.9200000000005
I_0_19_11 GND Node0_19_11 5.3403300000000106e-05A
R_0_19_11_1 Node0_19_11 Node0_19_12 76.99999999999984
R_0_19_11_2 Node0_19_11 Node0_20_11 76.99999999999984
R_0_19_11_3 Node0_19_11 Node1_19_11 3153.919999999994
I_0_19_12 GND Node0_19_12 6.290870000000012e-05A
R_0_19_12_1 Node0_19_12 Node0_19_13 76.99999999999984
R_0_19_12_2 Node0_19_12 Node0_20_12 76.99999999999984
R_0_19_12_3 Node0_19_12 Node1_19_12 3153.919999999994
I_0_19_13 GND Node0_19_13 7.503480000000015e-05A
R_0_19_13_1 Node0_19_13 Node0_19_14 76.99999999999991
R_0_19_13_2 Node0_19_13 Node0_20_13 76.99999999999984
R_0_19_13_3 Node0_19_13 Node1_19_13 3153.919999999994
I_0_19_14 GND Node0_19_14 8.758819e-05A
R_0_19_14_1 Node0_19_14 Node0_19_15 76.99999999999991
R_0_19_14_2 Node0_19_14 Node0_20_14 77.0
R_0_19_14_3 Node0_19_14 Node1_19_14 3153.9200000000005
I_0_19_15 GND Node0_19_15 9.723439000000019e-05A
R_0_19_15_1 Node0_19_15 Node0_19_16 76.99999999999984
R_0_19_15_2 Node0_19_15 Node0_20_15 76.99999999999984
R_0_19_15_3 Node0_19_15 Node1_19_15 3153.919999999994
I_0_19_16 GND Node0_19_16 0.0001008732000000002A
R_0_19_16_1 Node0_19_16 Node0_19_17 76.99999999999984
R_0_19_16_2 Node0_19_16 Node0_20_16 76.99999999999984
R_0_19_16_3 Node0_19_16 Node1_19_16 3153.919999999994
I_0_19_17 GND Node0_19_17 9.723439000000019e-05A
R_0_19_17_1 Node0_19_17 Node0_19_18 76.99999999999984
R_0_19_17_2 Node0_19_17 Node0_20_17 76.99999999999984
R_0_19_17_3 Node0_19_17 Node1_19_17 3153.919999999994
I_0_19_18 GND Node0_19_18 8.758819000000018e-05A
R_0_19_18_1 Node0_19_18 Node0_19_19 76.99999999999984
R_0_19_18_2 Node0_19_18 Node0_20_18 76.99999999999984
R_0_19_18_3 Node0_19_18 Node1_19_18 3153.919999999994
I_0_19_19 GND Node0_19_19 7.503480000000015e-05A
R_0_19_19_1 Node0_19_19 Node0_19_20 76.99999999999984
R_0_19_19_2 Node0_19_19 Node0_20_19 76.99999999999984
R_0_19_19_3 Node0_19_19 Node1_19_19 3153.919999999994
I_0_19_20 GND Node0_19_20 6.290870000000012e-05A
R_0_19_20_1 Node0_19_20 Node0_19_21 76.99999999999997
R_0_19_20_2 Node0_19_20 Node0_20_20 76.99999999999984
R_0_19_20_3 Node0_19_20 Node1_19_20 3153.919999999994
I_0_19_21 GND Node0_19_21 5.340329999999991e-05A
R_0_19_21_1 Node0_19_21 Node0_19_22 76.99999999999997
R_0_19_21_2 Node0_19_21 Node0_20_21 77.00000000000011
R_0_19_21_3 Node0_19_21 Node1_19_21 3153.920000000006
I_0_19_22 GND Node0_19_22 4.714443000000009e-05A
R_0_19_22_1 Node0_19_22 Node0_19_23 76.99999999999984
R_0_19_22_2 Node0_19_22 Node0_20_22 76.99999999999984
R_0_19_22_3 Node0_19_22 Node1_19_22 3153.919999999994
I_0_19_23 GND Node0_19_23 4.3623260000000085e-05A
R_0_19_23_1 Node0_19_23 Node0_19_24 76.99999999999984
R_0_19_23_2 Node0_19_23 Node0_20_23 76.99999999999984
R_0_19_23_3 Node0_19_23 Node1_19_23 3153.919999999994
I_0_19_24 GND Node0_19_24 4.191428000000008e-05A
R_0_19_24_1 Node0_19_24 Node0_19_25 76.99999999999984
R_0_19_24_2 Node0_19_24 Node0_20_24 76.99999999999984
R_0_19_24_3 Node0_19_24 Node1_19_24 3153.919999999994
I_0_19_25 GND Node0_19_25 4.119442000000008e-05A
R_0_19_25_1 Node0_19_25 Node0_19_26 76.99999999999984
R_0_19_25_2 Node0_19_25 Node0_20_25 76.99999999999984
R_0_19_25_3 Node0_19_25 Node1_19_25 3153.919999999994
I_0_19_26 GND Node0_19_26 4.0930200000000085e-05A
R_0_19_26_1 Node0_19_26 Node0_19_27 76.99999999999984
R_0_19_26_2 Node0_19_26 Node0_20_26 76.99999999999984
R_0_19_26_3 Node0_19_26 Node1_19_26 3153.919999999994
I_0_19_27 GND Node0_19_27 4.084547000000008e-05A
R_0_19_27_1 Node0_19_27 Node0_19_28 76.99999999999984
R_0_19_27_2 Node0_19_27 Node0_20_27 76.99999999999984
R_0_19_27_3 Node0_19_27 Node1_19_27 3153.919999999994
I_0_19_28 GND Node0_19_28 4.082168000000008e-05A
R_0_19_28_1 Node0_19_28 Node0_19_29 76.99999999999997
R_0_19_28_2 Node0_19_28 Node0_20_28 76.99999999999984
R_0_19_28_3 Node0_19_28 Node1_19_28 3153.919999999994
I_0_19_29 GND Node0_19_29 4.081581999999993e-05A
R_0_19_29_1 Node0_19_29 Node0_19_30 76.99999999999997
R_0_19_29_2 Node0_19_29 Node0_20_29 77.00000000000011
R_0_19_29_3 Node0_19_29 Node1_19_29 3153.920000000006
I_0_19_30 GND Node0_19_30 4.081455000000008e-05A
R_0_19_30_1 Node0_19_30 Node0_19_31 76.99999999999984
R_0_19_30_2 Node0_19_30 Node0_20_30 76.99999999999984
R_0_19_30_3 Node0_19_30 Node1_19_30 3153.919999999994
I_0_19_31 GND Node0_19_31 4.0814310000000075e-05A
R_0_19_31_2 Node0_19_31 Node0_20_31 76.99999999999984
R_0_19_31_3 Node0_19_31 Node1_19_31 3153.919999999994
I_0_20_0 GND Node0_20_0 4.0814270000000045e-05A
R_0_20_0_1 Node0_20_0 Node0_20_1 76.99999999999991
R_0_20_0_2 Node0_20_0 Node0_21_0 77.0
R_0_20_0_3 Node0_20_0 Node1_20_0 3153.9199999999973
I_0_20_1 GND Node0_20_1 4.0814290000000047e-05A
R_0_20_1_1 Node0_20_1 Node0_20_2 76.99999999999991
R_0_20_1_2 Node0_20_1 Node0_21_1 77.0
R_0_20_1_3 Node0_20_1 Node1_20_1 3153.9199999999973
I_0_20_2 GND Node0_20_2 4.081443000000005e-05A
R_0_20_2_1 Node0_20_2 Node0_20_3 76.99999999999991
R_0_20_2_2 Node0_20_2 Node0_21_2 77.0
R_0_20_2_3 Node0_20_2 Node1_20_2 3153.9199999999973
I_0_20_3 GND Node0_20_3 4.0815150000000046e-05A
R_0_20_3_1 Node0_20_3 Node0_20_4 76.99999999999991
R_0_20_3_2 Node0_20_3 Node0_21_3 77.0
R_0_20_3_3 Node0_20_3 Node1_20_3 3153.9199999999973
I_0_20_4 GND Node0_20_4 4.081849000000005e-05A
R_0_20_4_1 Node0_20_4 Node0_20_5 76.99999999999991
R_0_20_4_2 Node0_20_4 Node0_21_4 77.0
R_0_20_4_3 Node0_20_4 Node1_20_4 3153.9199999999973
I_0_20_5 GND Node0_20_5 4.083204000000004e-05A
R_0_20_5_1 Node0_20_5 Node0_20_6 76.99999999999991
R_0_20_5_2 Node0_20_5 Node0_21_5 77.0
R_0_20_5_3 Node0_20_5 Node1_20_5 3153.9199999999973
I_0_20_6 GND Node0_20_6 4.0880320000000044e-05A
R_0_20_6_1 Node0_20_6 Node0_20_7 76.99999999999991
R_0_20_6_2 Node0_20_6 Node0_21_6 77.0
R_0_20_6_3 Node0_20_6 Node1_20_6 3153.9199999999973
I_0_20_7 GND Node0_20_7 4.1030870000000046e-05A
R_0_20_7_1 Node0_20_7 Node0_20_8 76.99999999999989
R_0_20_7_2 Node0_20_7 Node0_21_7 77.0
R_0_20_7_3 Node0_20_7 Node1_20_7 3153.9199999999973
I_0_20_8 GND Node0_20_8 4.144103000000008e-05A
R_0_20_8_1 Node0_20_8 Node0_20_9 76.99999999999984
R_0_20_8_2 Node0_20_8 Node0_21_8 76.99999999999991
R_0_20_8_3 Node0_20_8 Node1_20_8 3153.919999999994
I_0_20_9 GND Node0_20_9 4.2414780000000086e-05A
R_0_20_9_1 Node0_20_9 Node0_20_10 76.99999999999991
R_0_20_9_2 Node0_20_9 Node0_21_9 76.99999999999991
R_0_20_9_3 Node0_20_9 Node1_20_9 3153.919999999994
I_0_20_10 GND Node0_20_10 4.442108e-05A
R_0_20_10_1 Node0_20_10 Node0_20_11 76.99999999999991
R_0_20_10_2 Node0_20_10 Node0_21_10 77.00000000000006
R_0_20_10_3 Node0_20_10 Node1_20_10 3153.9200000000005
I_0_20_11 GND Node0_20_11 4.7987280000000094e-05A
R_0_20_11_1 Node0_20_11 Node0_20_12 76.99999999999984
R_0_20_11_2 Node0_20_11 Node0_21_11 76.99999999999991
R_0_20_11_3 Node0_20_11 Node1_20_11 3153.919999999994
I_0_20_12 GND Node0_20_12 5.3403300000000106e-05A
R_0_20_12_1 Node0_20_12 Node0_20_13 76.99999999999984
R_0_20_12_2 Node0_20_12 Node0_21_12 76.99999999999991
R_0_20_12_3 Node0_20_12 Node1_20_12 3153.919999999994
I_0_20_13 GND Node0_20_13 6.031254000000012e-05A
R_0_20_13_1 Node0_20_13 Node0_20_14 76.99999999999991
R_0_20_13_2 Node0_20_13 Node0_21_13 76.99999999999991
R_0_20_13_3 Node0_20_13 Node1_20_13 3153.919999999994
I_0_20_14 GND Node0_20_14 6.746524e-05A
R_0_20_14_1 Node0_20_14 Node0_20_15 76.99999999999991
R_0_20_14_2 Node0_20_14 Node0_21_14 77.00000000000006
R_0_20_14_3 Node0_20_14 Node1_20_14 3153.9200000000005
I_0_20_15 GND Node0_20_15 7.296148000000015e-05A
R_0_20_15_1 Node0_20_15 Node0_20_16 76.99999999999984
R_0_20_15_2 Node0_20_15 Node0_21_15 76.99999999999991
R_0_20_15_3 Node0_20_15 Node1_20_15 3153.919999999994
I_0_20_16 GND Node0_20_16 7.503480000000015e-05A
R_0_20_16_1 Node0_20_16 Node0_20_17 76.99999999999984
R_0_20_16_2 Node0_20_16 Node0_21_16 76.99999999999991
R_0_20_16_3 Node0_20_16 Node1_20_16 3153.919999999994
I_0_20_17 GND Node0_20_17 7.296148000000015e-05A
R_0_20_17_1 Node0_20_17 Node0_20_18 76.99999999999984
R_0_20_17_2 Node0_20_17 Node0_21_17 76.99999999999991
R_0_20_17_3 Node0_20_17 Node1_20_17 3153.919999999994
I_0_20_18 GND Node0_20_18 6.746524000000013e-05A
R_0_20_18_1 Node0_20_18 Node0_20_19 76.99999999999984
R_0_20_18_2 Node0_20_18 Node0_21_18 76.99999999999991
R_0_20_18_3 Node0_20_18 Node1_20_18 3153.919999999994
I_0_20_19 GND Node0_20_19 6.031254000000012e-05A
R_0_20_19_1 Node0_20_19 Node0_20_20 76.99999999999984
R_0_20_19_2 Node0_20_19 Node0_21_19 76.99999999999991
R_0_20_19_3 Node0_20_19 Node1_20_19 3153.919999999994
I_0_20_20 GND Node0_20_20 5.3403300000000106e-05A
R_0_20_20_1 Node0_20_20 Node0_20_21 76.99999999999997
R_0_20_20_2 Node0_20_20 Node0_21_20 76.99999999999991
R_0_20_20_3 Node0_20_20 Node1_20_20 3153.919999999994
I_0_20_21 GND Node0_20_21 4.798727999999992e-05A
R_0_20_21_1 Node0_20_21 Node0_20_22 76.99999999999997
R_0_20_21_2 Node0_20_21 Node0_21_21 77.00000000000018
R_0_20_21_3 Node0_20_21 Node1_20_21 3153.920000000006
I_0_20_22 GND Node0_20_22 4.442108000000009e-05A
R_0_20_22_1 Node0_20_22 Node0_20_23 76.99999999999984
R_0_20_22_2 Node0_20_22 Node0_21_22 76.99999999999991
R_0_20_22_3 Node0_20_22 Node1_20_22 3153.919999999994
I_0_20_23 GND Node0_20_23 4.2414780000000086e-05A
R_0_20_23_1 Node0_20_23 Node0_20_24 76.99999999999984
R_0_20_23_2 Node0_20_23 Node0_21_23 76.99999999999991
R_0_20_23_3 Node0_20_23 Node1_20_23 3153.919999999994
I_0_20_24 GND Node0_20_24 4.144103000000008e-05A
R_0_20_24_1 Node0_20_24 Node0_20_25 76.99999999999984
R_0_20_24_2 Node0_20_24 Node0_21_24 76.99999999999991
R_0_20_24_3 Node0_20_24 Node1_20_24 3153.919999999994
I_0_20_25 GND Node0_20_25 4.103087000000008e-05A
R_0_20_25_1 Node0_20_25 Node0_20_26 76.99999999999984
R_0_20_25_2 Node0_20_25 Node0_21_25 76.99999999999991
R_0_20_25_3 Node0_20_25 Node1_20_25 3153.919999999994
I_0_20_26 GND Node0_20_26 4.088032000000008e-05A
R_0_20_26_1 Node0_20_26 Node0_20_27 76.99999999999984
R_0_20_26_2 Node0_20_26 Node0_21_26 76.99999999999991
R_0_20_26_3 Node0_20_26 Node1_20_26 3153.919999999994
I_0_20_27 GND Node0_20_27 4.0832040000000075e-05A
R_0_20_27_1 Node0_20_27 Node0_20_28 76.99999999999984
R_0_20_27_2 Node0_20_27 Node0_21_27 76.99999999999991
R_0_20_27_3 Node0_20_27 Node1_20_27 3153.919999999994
I_0_20_28 GND Node0_20_28 4.081849000000008e-05A
R_0_20_28_1 Node0_20_28 Node0_20_29 76.99999999999997
R_0_20_28_2 Node0_20_28 Node0_21_28 76.99999999999991
R_0_20_28_3 Node0_20_28 Node1_20_28 3153.919999999994
I_0_20_29 GND Node0_20_29 4.081514999999993e-05A
R_0_20_29_1 Node0_20_29 Node0_20_30 76.99999999999997
R_0_20_29_2 Node0_20_29 Node0_21_29 77.00000000000018
R_0_20_29_3 Node0_20_29 Node1_20_29 3153.920000000006
I_0_20_30 GND Node0_20_30 4.0814430000000083e-05A
R_0_20_30_1 Node0_20_30 Node0_20_31 76.99999999999984
R_0_20_30_2 Node0_20_30 Node0_21_30 76.99999999999991
R_0_20_30_3 Node0_20_30 Node1_20_30 3153.919999999994
I_0_20_31 GND Node0_20_31 4.081429000000008e-05A
R_0_20_31_2 Node0_20_31 Node0_21_31 76.99999999999991
R_0_20_31_3 Node0_20_31 Node1_20_31 3153.919999999994
I_0_21_0 GND Node0_21_0 4.0814269999999964e-05A
R_0_21_0_1 Node0_21_0 Node0_21_1 77.00000000000007
R_0_21_0_2 Node0_21_0 Node0_22_0 77.0
R_0_21_0_3 Node0_21_0 Node1_21_0 3153.9200000000033
I_0_21_1 GND Node0_21_1 4.0814279999999965e-05A
R_0_21_1_1 Node0_21_1 Node0_21_2 77.00000000000007
R_0_21_1_2 Node0_21_1 Node0_22_1 77.0
R_0_21_1_3 Node0_21_1 Node1_21_1 3153.9200000000033
I_0_21_2 GND Node0_21_2 4.081434999999997e-05A
R_0_21_2_1 Node0_21_2 Node0_21_3 77.00000000000007
R_0_21_2_2 Node0_21_2 Node0_22_2 77.0
R_0_21_2_3 Node0_21_2 Node1_21_2 3153.9200000000033
I_0_21_3 GND Node0_21_3 4.081470999999997e-05A
R_0_21_3_1 Node0_21_3 Node0_21_4 77.00000000000007
R_0_21_3_2 Node0_21_3 Node0_22_3 77.0
R_0_21_3_3 Node0_21_3 Node1_21_3 3153.9200000000033
I_0_21_4 GND Node0_21_4 4.081638999999996e-05A
R_0_21_4_1 Node0_21_4 Node0_21_5 77.00000000000007
R_0_21_4_2 Node0_21_4 Node0_22_4 77.0
R_0_21_4_3 Node0_21_4 Node1_21_4 3153.9200000000033
I_0_21_5 GND Node0_21_5 4.0823199999999965e-05A
R_0_21_5_1 Node0_21_5 Node0_21_6 77.00000000000007
R_0_21_5_2 Node0_21_5 Node0_22_5 77.0
R_0_21_5_3 Node0_21_5 Node1_21_5 3153.9200000000033
I_0_21_6 GND Node0_21_6 4.084747999999996e-05A
R_0_21_6_1 Node0_21_6 Node0_21_7 77.00000000000007
R_0_21_6_2 Node0_21_6 Node0_22_6 77.0
R_0_21_6_3 Node0_21_6 Node1_21_6 3153.9200000000033
I_0_21_7 GND Node0_21_7 4.0923179999999966e-05A
R_0_21_7_1 Node0_21_7 Node0_21_8 77.00000000000003
R_0_21_7_2 Node0_21_7 Node0_22_7 77.0
R_0_21_7_3 Node0_21_7 Node1_21_7 3153.9200000000033
I_0_21_8 GND Node0_21_8 4.112942e-05A
R_0_21_8_1 Node0_21_8 Node0_21_9 77.0
R_0_21_8_2 Node0_21_8 Node0_22_8 76.99999999999991
R_0_21_8_3 Node0_21_8 Node1_21_8 3153.9200000000005
I_0_21_9 GND Node0_21_9 4.161905e-05A
R_0_21_9_1 Node0_21_9 Node0_21_10 77.00000000000006
R_0_21_9_2 Node0_21_9 Node0_22_9 76.99999999999991
R_0_21_9_3 Node0_21_9 Node1_21_9 3153.9200000000005
I_0_21_10 GND Node0_21_10 4.262788999999993e-05A
R_0_21_10_1 Node0_21_10 Node0_21_11 77.00000000000006
R_0_21_10_2 Node0_21_10 Node0_22_10 77.00000000000006
R_0_21_10_3 Node0_21_10 Node1_21_10 3153.920000000006
I_0_21_11 GND Node0_21_11 4.442108e-05A
R_0_21_11_1 Node0_21_11 Node0_21_12 77.0
R_0_21_11_2 Node0_21_11 Node0_22_11 76.99999999999991
R_0_21_11_3 Node0_21_11 Node1_21_11 3153.9200000000005
I_0_21_12 GND Node0_21_12 4.714443e-05A
R_0_21_12_1 Node0_21_12 Node0_21_13 77.0
R_0_21_12_2 Node0_21_12 Node0_22_12 76.99999999999991
R_0_21_12_3 Node0_21_12 Node1_21_12 3153.9200000000005
I_0_21_13 GND Node0_21_13 5.061861e-05A
R_0_21_13_1 Node0_21_13 Node0_21_14 77.00000000000006
R_0_21_13_2 Node0_21_13 Node0_22_13 76.99999999999991
R_0_21_13_3 Node0_21_13 Node1_21_13 3153.9200000000005
I_0_21_14 GND Node0_21_14 5.421521999999991e-05A
R_0_21_14_1 Node0_21_14 Node0_21_15 77.00000000000006
R_0_21_14_2 Node0_21_14 Node0_22_14 77.00000000000006
R_0_21_14_3 Node0_21_14 Node1_21_14 3153.920000000006
I_0_21_15 GND Node0_21_15 5.69789e-05A
R_0_21_15_1 Node0_21_15 Node0_21_16 77.0
R_0_21_15_2 Node0_21_15 Node0_22_15 76.99999999999991
R_0_21_15_3 Node0_21_15 Node1_21_15 3153.9200000000005
I_0_21_16 GND Node0_21_16 5.802143e-05A
R_0_21_16_1 Node0_21_16 Node0_21_17 77.0
R_0_21_16_2 Node0_21_16 Node0_22_16 76.99999999999991
R_0_21_16_3 Node0_21_16 Node1_21_16 3153.9200000000005
I_0_21_17 GND Node0_21_17 5.69789e-05A
R_0_21_17_1 Node0_21_17 Node0_21_18 77.0
R_0_21_17_2 Node0_21_17 Node0_22_17 76.99999999999991
R_0_21_17_3 Node0_21_17 Node1_21_17 3153.9200000000005
I_0_21_18 GND Node0_21_18 5.421522e-05A
R_0_21_18_1 Node0_21_18 Node0_21_19 77.0
R_0_21_18_2 Node0_21_18 Node0_22_18 76.99999999999991
R_0_21_18_3 Node0_21_18 Node1_21_18 3153.9200000000005
I_0_21_19 GND Node0_21_19 5.061861e-05A
R_0_21_19_1 Node0_21_19 Node0_21_20 77.0
R_0_21_19_2 Node0_21_19 Node0_22_19 76.99999999999991
R_0_21_19_3 Node0_21_19 Node1_21_19 3153.9200000000005
I_0_21_20 GND Node0_21_20 4.714443e-05A
R_0_21_20_1 Node0_21_20 Node0_21_21 77.00000000000013
R_0_21_20_2 Node0_21_20 Node0_22_20 76.99999999999991
R_0_21_20_3 Node0_21_20 Node1_21_20 3153.9200000000005
I_0_21_21 GND Node0_21_21 4.442107999999985e-05A
R_0_21_21_1 Node0_21_21 Node0_21_22 77.00000000000013
R_0_21_21_2 Node0_21_21 Node0_22_21 77.00000000000018
R_0_21_21_3 Node0_21_21 Node1_21_21 3153.920000000011
I_0_21_22 GND Node0_21_22 4.262789e-05A
R_0_21_22_1 Node0_21_22 Node0_21_23 77.0
R_0_21_22_2 Node0_21_22 Node0_22_22 76.99999999999991
R_0_21_22_3 Node0_21_22 Node1_21_22 3153.9200000000005
I_0_21_23 GND Node0_21_23 4.161905e-05A
R_0_21_23_1 Node0_21_23 Node0_21_24 77.0
R_0_21_23_2 Node0_21_23 Node0_22_23 76.99999999999991
R_0_21_23_3 Node0_21_23 Node1_21_23 3153.9200000000005
I_0_21_24 GND Node0_21_24 4.112942e-05A
R_0_21_24_1 Node0_21_24 Node0_21_25 77.0
R_0_21_24_2 Node0_21_24 Node0_22_24 76.99999999999991
R_0_21_24_3 Node0_21_24 Node1_21_24 3153.9200000000005
I_0_21_25 GND Node0_21_25 4.092318e-05A
R_0_21_25_1 Node0_21_25 Node0_21_26 77.0
R_0_21_25_2 Node0_21_25 Node0_22_25 76.99999999999991
R_0_21_25_3 Node0_21_25 Node1_21_25 3153.9200000000005
I_0_21_26 GND Node0_21_26 4.084748e-05A
R_0_21_26_1 Node0_21_26 Node0_21_27 77.0
R_0_21_26_2 Node0_21_26 Node0_22_26 76.99999999999991
R_0_21_26_3 Node0_21_26 Node1_21_26 3153.9200000000005
I_0_21_27 GND Node0_21_27 4.08232e-05A
R_0_21_27_1 Node0_21_27 Node0_21_28 77.0
R_0_21_27_2 Node0_21_27 Node0_22_27 76.99999999999991
R_0_21_27_3 Node0_21_27 Node1_21_27 3153.9200000000005
I_0_21_28 GND Node0_21_28 4.081639e-05A
R_0_21_28_1 Node0_21_28 Node0_21_29 77.00000000000013
R_0_21_28_2 Node0_21_28 Node0_22_28 76.99999999999991
R_0_21_28_3 Node0_21_28 Node1_21_28 3153.9200000000005
I_0_21_29 GND Node0_21_29 4.0814709999999866e-05A
R_0_21_29_1 Node0_21_29 Node0_21_30 77.00000000000013
R_0_21_29_2 Node0_21_29 Node0_22_29 77.00000000000018
R_0_21_29_3 Node0_21_29 Node1_21_29 3153.920000000011
I_0_21_30 GND Node0_21_30 4.081435e-05A
R_0_21_30_1 Node0_21_30 Node0_21_31 77.0
R_0_21_30_2 Node0_21_30 Node0_22_30 76.99999999999991
R_0_21_30_3 Node0_21_30 Node1_21_30 3153.9200000000005
I_0_21_31 GND Node0_21_31 4.081428e-05A
R_0_21_31_2 Node0_21_31 Node0_22_31 76.99999999999991
R_0_21_31_3 Node0_21_31 Node1_21_31 3153.9200000000005
I_0_22_0 GND Node0_22_0 4.0814260000000044e-05A
R_0_22_0_1 Node0_22_0 Node0_22_1 76.99999999999991
R_0_22_0_2 Node0_22_0 Node0_23_0 76.99999999999991
R_0_22_0_3 Node0_22_0 Node1_22_0 3153.9199999999973
I_0_22_1 GND Node0_22_1 4.0814270000000045e-05A
R_0_22_1_1 Node0_22_1 Node0_22_2 76.99999999999991
R_0_22_1_2 Node0_22_1 Node0_23_1 76.99999999999991
R_0_22_1_3 Node0_22_1 Node1_22_1 3153.9199999999973
I_0_22_2 GND Node0_22_2 4.081430000000005e-05A
R_0_22_2_1 Node0_22_2 Node0_22_3 76.99999999999991
R_0_22_2_2 Node0_22_2 Node0_23_2 76.99999999999991
R_0_22_2_3 Node0_22_2 Node1_22_2 3153.9199999999973
I_0_22_3 GND Node0_22_3 4.0814460000000045e-05A
R_0_22_3_1 Node0_22_3 Node0_22_4 76.99999999999991
R_0_22_3_2 Node0_22_3 Node0_23_3 76.99999999999991
R_0_22_3_3 Node0_22_3 Node1_22_3 3153.9199999999973
I_0_22_4 GND Node0_22_4 4.081521000000005e-05A
R_0_22_4_1 Node0_22_4 Node0_22_5 76.99999999999991
R_0_22_4_2 Node0_22_4 Node0_23_4 76.99999999999991
R_0_22_4_3 Node0_22_4 Node1_22_4 3153.9199999999973
I_0_22_5 GND Node0_22_5 4.0818230000000044e-05A
R_0_22_5_1 Node0_22_5 Node0_22_6 76.99999999999991
R_0_22_5_2 Node0_22_5 Node0_23_5 76.99999999999991
R_0_22_5_3 Node0_22_5 Node1_22_5 3153.9199999999973
I_0_22_6 GND Node0_22_6 4.0829000000000046e-05A
R_0_22_6_1 Node0_22_6 Node0_22_7 76.99999999999991
R_0_22_6_2 Node0_22_6 Node0_23_6 76.99999999999991
R_0_22_6_3 Node0_22_6 Node1_22_6 3153.9199999999973
I_0_22_7 GND Node0_22_7 4.0862590000000044e-05A
R_0_22_7_1 Node0_22_7 Node0_22_8 76.99999999999989
R_0_22_7_2 Node0_22_7 Node0_23_7 76.99999999999991
R_0_22_7_3 Node0_22_7 Node1_22_7 3153.9199999999973
I_0_22_8 GND Node0_22_8 4.0954110000000083e-05A
R_0_22_8_1 Node0_22_8 Node0_22_9 76.99999999999984
R_0_22_8_2 Node0_22_8 Node0_23_8 76.99999999999984
R_0_22_8_3 Node0_22_8 Node1_22_8 3153.919999999994
I_0_22_9 GND Node0_22_9 4.1171390000000084e-05A
R_0_22_9_1 Node0_22_9 Node0_22_10 76.99999999999991
R_0_22_9_2 Node0_22_9 Node0_23_9 76.99999999999984
R_0_22_9_3 Node0_22_9 Node1_22_9 3153.919999999994
I_0_22_10 GND Node0_22_10 4.161905e-05A
R_0_22_10_1 Node0_22_10 Node0_22_11 76.99999999999991
R_0_22_10_2 Node0_22_10 Node0_23_10 77.0
R_0_22_10_3 Node0_22_10 Node1_22_10 3153.9200000000005
I_0_22_11 GND Node0_22_11 4.2414780000000086e-05A
R_0_22_11_1 Node0_22_11 Node0_22_12 76.99999999999984
R_0_22_11_2 Node0_22_11 Node0_23_11 76.99999999999984
R_0_22_11_3 Node0_22_11 Node1_22_11 3153.919999999994
I_0_22_12 GND Node0_22_12 4.3623260000000085e-05A
R_0_22_12_1 Node0_22_12 Node0_22_13 76.99999999999984
R_0_22_12_2 Node0_22_12 Node0_23_12 76.99999999999984
R_0_22_12_3 Node0_22_12 Node1_22_12 3153.919999999994
I_0_22_13 GND Node0_22_13 4.516492000000009e-05A
R_0_22_13_1 Node0_22_13 Node0_22_14 76.99999999999991
R_0_22_13_2 Node0_22_13 Node0_23_13 76.99999999999984
R_0_22_13_3 Node0_22_13 Node1_22_13 3153.919999999994
I_0_22_14 GND Node0_22_14 4.67609e-05A
R_0_22_14_1 Node0_22_14 Node0_22_15 76.99999999999991
R_0_22_14_2 Node0_22_14 Node0_23_14 77.0
R_0_22_14_3 Node0_22_14 Node1_22_14 3153.9200000000005
I_0_22_15 GND Node0_22_15 4.7987280000000094e-05A
R_0_22_15_1 Node0_22_15 Node0_22_16 76.99999999999984
R_0_22_15_2 Node0_22_15 Node0_23_15 76.99999999999984
R_0_22_15_3 Node0_22_15 Node1_22_15 3153.919999999994
I_0_22_16 GND Node0_22_16 4.844990000000009e-05A
R_0_22_16_1 Node0_22_16 Node0_22_17 76.99999999999984
R_0_22_16_2 Node0_22_16 Node0_23_16 76.99999999999984
R_0_22_16_3 Node0_22_16 Node1_22_16 3153.919999999994
I_0_22_17 GND Node0_22_17 4.7987280000000094e-05A
R_0_22_17_1 Node0_22_17 Node0_22_18 76.99999999999984
R_0_22_17_2 Node0_22_17 Node0_23_17 76.99999999999984
R_0_22_17_3 Node0_22_17 Node1_22_17 3153.919999999994
I_0_22_18 GND Node0_22_18 4.6760900000000096e-05A
R_0_22_18_1 Node0_22_18 Node0_22_19 76.99999999999984
R_0_22_18_2 Node0_22_18 Node0_23_18 76.99999999999984
R_0_22_18_3 Node0_22_18 Node1_22_18 3153.919999999994
I_0_22_19 GND Node0_22_19 4.516492000000009e-05A
R_0_22_19_1 Node0_22_19 Node0_22_20 76.99999999999984
R_0_22_19_2 Node0_22_19 Node0_23_19 76.99999999999984
R_0_22_19_3 Node0_22_19 Node1_22_19 3153.919999999994
I_0_22_20 GND Node0_22_20 4.3623260000000085e-05A
R_0_22_20_1 Node0_22_20 Node0_22_21 76.99999999999997
R_0_22_20_2 Node0_22_20 Node0_23_20 76.99999999999984
R_0_22_20_3 Node0_22_20 Node1_22_20 3153.919999999994
I_0_22_21 GND Node0_22_21 4.241477999999993e-05A
R_0_22_21_1 Node0_22_21 Node0_22_22 76.99999999999997
R_0_22_21_2 Node0_22_21 Node0_23_21 77.00000000000011
R_0_22_21_3 Node0_22_21 Node1_22_21 3153.920000000006
I_0_22_22 GND Node0_22_22 4.161905000000008e-05A
R_0_22_22_1 Node0_22_22 Node0_22_23 76.99999999999984
R_0_22_22_2 Node0_22_22 Node0_23_22 76.99999999999984
R_0_22_22_3 Node0_22_22 Node1_22_22 3153.919999999994
I_0_22_23 GND Node0_22_23 4.1171390000000084e-05A
R_0_22_23_1 Node0_22_23 Node0_22_24 76.99999999999984
R_0_22_23_2 Node0_22_23 Node0_23_23 76.99999999999984
R_0_22_23_3 Node0_22_23 Node1_22_23 3153.919999999994
I_0_22_24 GND Node0_22_24 4.0954110000000083e-05A
R_0_22_24_1 Node0_22_24 Node0_22_25 76.99999999999984
R_0_22_24_2 Node0_22_24 Node0_23_24 76.99999999999984
R_0_22_24_3 Node0_22_24 Node1_22_24 3153.919999999994
I_0_22_25 GND Node0_22_25 4.086259000000008e-05A
R_0_22_25_1 Node0_22_25 Node0_22_26 76.99999999999984
R_0_22_25_2 Node0_22_25 Node0_23_25 76.99999999999984
R_0_22_25_3 Node0_22_25 Node1_22_25 3153.919999999994
I_0_22_26 GND Node0_22_26 4.082900000000008e-05A
R_0_22_26_1 Node0_22_26 Node0_22_27 76.99999999999984
R_0_22_26_2 Node0_22_26 Node0_23_26 76.99999999999984
R_0_22_26_3 Node0_22_26 Node1_22_26 3153.919999999994
I_0_22_27 GND Node0_22_27 4.081823000000008e-05A
R_0_22_27_1 Node0_22_27 Node0_22_28 76.99999999999984
R_0_22_27_2 Node0_22_27 Node0_23_27 76.99999999999984
R_0_22_27_3 Node0_22_27 Node1_22_27 3153.919999999994
I_0_22_28 GND Node0_22_28 4.0815210000000084e-05A
R_0_22_28_1 Node0_22_28 Node0_22_29 76.99999999999997
R_0_22_28_2 Node0_22_28 Node0_23_28 76.99999999999984
R_0_22_28_3 Node0_22_28 Node1_22_28 3153.919999999994
I_0_22_29 GND Node0_22_29 4.081445999999993e-05A
R_0_22_29_1 Node0_22_29 Node0_22_30 76.99999999999997
R_0_22_29_2 Node0_22_29 Node0_23_29 77.00000000000011
R_0_22_29_3 Node0_22_29 Node1_22_29 3153.920000000006
I_0_22_30 GND Node0_22_30 4.081430000000008e-05A
R_0_22_30_1 Node0_22_30 Node0_22_31 76.99999999999984
R_0_22_30_2 Node0_22_30 Node0_23_30 76.99999999999984
R_0_22_30_3 Node0_22_30 Node1_22_30 3153.919999999994
I_0_22_31 GND Node0_22_31 4.081427000000008e-05A
R_0_22_31_2 Node0_22_31 Node0_23_31 76.99999999999984
R_0_22_31_3 Node0_22_31 Node1_22_31 3153.919999999994
I_0_23_0 GND Node0_23_0 4.0814260000000044e-05A
R_0_23_0_1 Node0_23_0 Node0_23_1 76.99999999999991
R_0_23_0_2 Node0_23_0 Node0_24_0 76.99999999999996
R_0_23_0_3 Node0_23_0 Node1_23_0 3153.9199999999973
I_0_23_1 GND Node0_23_1 4.0814270000000045e-05A
R_0_23_1_1 Node0_23_1 Node0_23_2 76.99999999999991
R_0_23_1_2 Node0_23_1 Node0_24_1 76.99999999999996
R_0_23_1_3 Node0_23_1 Node1_23_1 3153.9199999999973
I_0_23_2 GND Node0_23_2 4.0814280000000046e-05A
R_0_23_2_1 Node0_23_2 Node0_23_3 76.99999999999991
R_0_23_2_2 Node0_23_2 Node0_24_2 76.99999999999996
R_0_23_2_3 Node0_23_2 Node1_23_2 3153.9199999999973
I_0_23_3 GND Node0_23_3 4.081434000000005e-05A
R_0_23_3_1 Node0_23_3 Node0_23_4 76.99999999999991
R_0_23_3_2 Node0_23_3 Node0_24_3 76.99999999999996
R_0_23_3_3 Node0_23_3 Node1_23_3 3153.9199999999973
I_0_23_4 GND Node0_23_4 4.081463000000004e-05A
R_0_23_4_1 Node0_23_4 Node0_23_5 76.99999999999991
R_0_23_4_2 Node0_23_4 Node0_24_4 76.99999999999996
R_0_23_4_3 Node0_23_4 Node1_23_4 3153.9199999999973
I_0_23_5 GND Node0_23_5 4.0815820000000045e-05A
R_0_23_5_1 Node0_23_5 Node0_23_6 76.99999999999991
R_0_23_5_2 Node0_23_5 Node0_24_5 76.99999999999996
R_0_23_5_3 Node0_23_5 Node1_23_5 3153.9199999999973
I_0_23_6 GND Node0_23_6 4.082004000000005e-05A
R_0_23_6_1 Node0_23_6 Node0_23_7 76.99999999999991
R_0_23_6_2 Node0_23_6 Node0_24_6 76.99999999999996
R_0_23_6_3 Node0_23_6 Node1_23_6 3153.9199999999973
I_0_23_7 GND Node0_23_7 4.083319000000005e-05A
R_0_23_7_1 Node0_23_7 Node0_23_8 76.99999999999989
R_0_23_7_2 Node0_23_7 Node0_24_7 76.99999999999996
R_0_23_7_3 Node0_23_7 Node1_23_7 3153.9199999999973
I_0_23_8 GND Node0_23_8 4.086903000000008e-05A
R_0_23_8_1 Node0_23_8 Node0_23_9 76.99999999999984
R_0_23_8_2 Node0_23_8 Node0_24_8 76.99999999999989
R_0_23_8_3 Node0_23_8 Node1_23_8 3153.919999999994
I_0_23_9 GND Node0_23_9 4.0954110000000083e-05A
R_0_23_9_1 Node0_23_9 Node0_23_10 76.99999999999991
R_0_23_9_2 Node0_23_9 Node0_24_9 76.99999999999989
R_0_23_9_3 Node0_23_9 Node1_23_9 3153.919999999994
I_0_23_10 GND Node0_23_10 4.112942e-05A
R_0_23_10_1 Node0_23_10 Node0_23_11 76.99999999999991
R_0_23_10_2 Node0_23_10 Node0_24_10 77.00000000000003
R_0_23_10_3 Node0_23_10 Node1_23_10 3153.9200000000005
I_0_23_11 GND Node0_23_11 4.144103000000008e-05A
R_0_23_11_1 Node0_23_11 Node0_23_12 76.99999999999984
R_0_23_11_2 Node0_23_11 Node0_24_11 76.99999999999989
R_0_23_11_3 Node0_23_11 Node1_23_11 3153.919999999994
I_0_23_12 GND Node0_23_12 4.191428000000008e-05A
R_0_23_12_1 Node0_23_12 Node0_23_13 76.99999999999984
R_0_23_12_2 Node0_23_12 Node0_24_12 76.99999999999989
R_0_23_12_3 Node0_23_12 Node1_23_12 3153.919999999994
I_0_23_13 GND Node0_23_13 4.251800000000009e-05A
R_0_23_13_1 Node0_23_13 Node0_23_14 76.99999999999991
R_0_23_13_2 Node0_23_13 Node0_24_13 76.99999999999989
R_0_23_13_3 Node0_23_13 Node1_23_13 3153.919999999994
I_0_23_14 GND Node0_23_14 4.3143e-05A
R_0_23_14_1 Node0_23_14 Node0_23_15 76.99999999999991
R_0_23_14_2 Node0_23_14 Node0_24_14 77.00000000000003
R_0_23_14_3 Node0_23_14 Node1_23_14 3153.9200000000005
I_0_23_15 GND Node0_23_15 4.3623260000000085e-05A
R_0_23_15_1 Node0_23_15 Node0_23_16 76.99999999999984
R_0_23_15_2 Node0_23_15 Node0_24_15 76.99999999999989
R_0_23_15_3 Node0_23_15 Node1_23_15 3153.919999999994
I_0_23_16 GND Node0_23_16 4.3804420000000086e-05A
R_0_23_16_1 Node0_23_16 Node0_23_17 76.99999999999984
R_0_23_16_2 Node0_23_16 Node0_24_16 76.99999999999989
R_0_23_16_3 Node0_23_16 Node1_23_16 3153.919999999994
I_0_23_17 GND Node0_23_17 4.3623260000000085e-05A
R_0_23_17_1 Node0_23_17 Node0_23_18 76.99999999999984
R_0_23_17_2 Node0_23_17 Node0_24_17 76.99999999999989
R_0_23_17_3 Node0_23_17 Node1_23_17 3153.919999999994
I_0_23_18 GND Node0_23_18 4.3143000000000085e-05A
R_0_23_18_1 Node0_23_18 Node0_23_19 76.99999999999984
R_0_23_18_2 Node0_23_18 Node0_24_18 76.99999999999989
R_0_23_18_3 Node0_23_18 Node1_23_18 3153.919999999994
I_0_23_19 GND Node0_23_19 4.251800000000009e-05A
R_0_23_19_1 Node0_23_19 Node0_23_20 76.99999999999984
R_0_23_19_2 Node0_23_19 Node0_24_19 76.99999999999989
R_0_23_19_3 Node0_23_19 Node1_23_19 3153.919999999994
I_0_23_20 GND Node0_23_20 4.191428000000008e-05A
R_0_23_20_1 Node0_23_20 Node0_23_21 76.99999999999997
R_0_23_20_2 Node0_23_20 Node0_24_20 76.99999999999989
R_0_23_20_3 Node0_23_20 Node1_23_20 3153.919999999994
I_0_23_21 GND Node0_23_21 4.144102999999993e-05A
R_0_23_21_1 Node0_23_21 Node0_23_22 76.99999999999997
R_0_23_21_2 Node0_23_21 Node0_24_21 77.00000000000014
R_0_23_21_3 Node0_23_21 Node1_23_21 3153.920000000006
I_0_23_22 GND Node0_23_22 4.112942000000008e-05A
R_0_23_22_1 Node0_23_22 Node0_23_23 76.99999999999984
R_0_23_22_2 Node0_23_22 Node0_24_22 76.99999999999989
R_0_23_22_3 Node0_23_22 Node1_23_22 3153.919999999994
I_0_23_23 GND Node0_23_23 4.0954110000000083e-05A
R_0_23_23_1 Node0_23_23 Node0_23_24 76.99999999999984
R_0_23_23_2 Node0_23_23 Node0_24_23 76.99999999999989
R_0_23_23_3 Node0_23_23 Node1_23_23 3153.919999999994
I_0_23_24 GND Node0_23_24 4.086903000000008e-05A
R_0_23_24_1 Node0_23_24 Node0_23_25 76.99999999999984
R_0_23_24_2 Node0_23_24 Node0_24_24 76.99999999999989
R_0_23_24_3 Node0_23_24 Node1_23_24 3153.919999999994
I_0_23_25 GND Node0_23_25 4.083319000000008e-05A
R_0_23_25_1 Node0_23_25 Node0_23_26 76.99999999999984
R_0_23_25_2 Node0_23_25 Node0_24_25 76.99999999999989
R_0_23_25_3 Node0_23_25 Node1_23_25 3153.919999999994
I_0_23_26 GND Node0_23_26 4.082004000000008e-05A
R_0_23_26_1 Node0_23_26 Node0_23_27 76.99999999999984
R_0_23_26_2 Node0_23_26 Node0_24_26 76.99999999999989
R_0_23_26_3 Node0_23_26 Node1_23_26 3153.919999999994
I_0_23_27 GND Node0_23_27 4.081582000000008e-05A
R_0_23_27_1 Node0_23_27 Node0_23_28 76.99999999999984
R_0_23_27_2 Node0_23_27 Node0_24_27 76.99999999999989
R_0_23_27_3 Node0_23_27 Node1_23_27 3153.919999999994
I_0_23_28 GND Node0_23_28 4.081463000000008e-05A
R_0_23_28_1 Node0_23_28 Node0_23_29 76.99999999999997
R_0_23_28_2 Node0_23_28 Node0_24_28 76.99999999999989
R_0_23_28_3 Node0_23_28 Node1_23_28 3153.919999999994
I_0_23_29 GND Node0_23_29 4.0814339999999935e-05A
R_0_23_29_1 Node0_23_29 Node0_23_30 76.99999999999997
R_0_23_29_2 Node0_23_29 Node0_24_29 77.00000000000014
R_0_23_29_3 Node0_23_29 Node1_23_29 3153.920000000006
I_0_23_30 GND Node0_23_30 4.081428000000008e-05A
R_0_23_30_1 Node0_23_30 Node0_23_31 76.99999999999984
R_0_23_30_2 Node0_23_30 Node0_24_30 76.99999999999989
R_0_23_30_3 Node0_23_30 Node1_23_30 3153.919999999994
I_0_23_31 GND Node0_23_31 4.081427000000008e-05A
R_0_23_31_2 Node0_23_31 Node0_24_31 76.99999999999989
R_0_23_31_3 Node0_23_31 Node1_23_31 3153.919999999994
I_0_24_0 GND Node0_24_0 4.081426e-05A
R_0_24_0_1 Node0_24_0 Node0_24_1 77.0
R_0_24_0_2 Node0_24_0 Node0_25_0 77.0
R_0_24_0_3 Node0_24_0 Node1_24_0 3153.9200000000005
I_0_24_1 GND Node0_24_1 4.081426e-05A
R_0_24_1_1 Node0_24_1 Node0_24_2 77.0
R_0_24_1_2 Node0_24_1 Node0_25_1 77.0
R_0_24_1_3 Node0_24_1 Node1_24_1 3153.9200000000005
I_0_24_2 GND Node0_24_2 4.081427e-05A
R_0_24_2_1 Node0_24_2 Node0_24_3 77.0
R_0_24_2_2 Node0_24_2 Node0_25_2 77.0
R_0_24_2_3 Node0_24_2 Node1_24_2 3153.9200000000005
I_0_24_3 GND Node0_24_3 4.081429e-05A
R_0_24_3_1 Node0_24_3 Node0_24_4 77.0
R_0_24_3_2 Node0_24_3 Node0_25_3 77.0
R_0_24_3_3 Node0_24_3 Node1_24_3 3153.9200000000005
I_0_24_4 GND Node0_24_4 4.081439e-05A
R_0_24_4_1 Node0_24_4 Node0_24_5 77.0
R_0_24_4_2 Node0_24_4 Node0_25_4 77.0
R_0_24_4_3 Node0_24_4 Node1_24_4 3153.9200000000005
I_0_24_5 GND Node0_24_5 4.08148e-05A
R_0_24_5_1 Node0_24_5 Node0_24_6 77.0
R_0_24_5_2 Node0_24_5 Node0_25_5 77.0
R_0_24_5_3 Node0_24_5 Node1_24_5 3153.9200000000005
I_0_24_6 GND Node0_24_6 4.0816259999999995e-05A
R_0_24_6_1 Node0_24_6 Node0_24_7 77.0
R_0_24_6_2 Node0_24_6 Node0_25_6 77.0
R_0_24_6_3 Node0_24_6 Node1_24_6 3153.9200000000005
I_0_24_7 GND Node0_24_7 4.08208e-05A
R_0_24_7_1 Node0_24_7 Node0_24_8 76.99999999999996
R_0_24_7_2 Node0_24_7 Node0_25_7 77.0
R_0_24_7_3 Node0_24_7 Node1_24_7 3153.9200000000005
I_0_24_8 GND Node0_24_8 4.083319000000005e-05A
R_0_24_8_1 Node0_24_8 Node0_24_9 76.99999999999991
R_0_24_8_2 Node0_24_8 Node0_25_8 76.99999999999991
R_0_24_8_3 Node0_24_8 Node1_24_8 3153.9199999999973
I_0_24_9 GND Node0_24_9 4.0862590000000044e-05A
R_0_24_9_1 Node0_24_9 Node0_24_10 77.0
R_0_24_9_2 Node0_24_9 Node0_25_9 76.99999999999991
R_0_24_9_3 Node0_24_9 Node1_24_9 3153.9199999999973
I_0_24_10 GND Node0_24_10 4.0923179999999966e-05A
R_0_24_10_1 Node0_24_10 Node0_24_11 77.0
R_0_24_10_2 Node0_24_10 Node0_25_10 77.00000000000007
R_0_24_10_3 Node0_24_10 Node1_24_10 3153.9200000000033
I_0_24_11 GND Node0_24_11 4.1030870000000046e-05A
R_0_24_11_1 Node0_24_11 Node0_24_12 76.99999999999991
R_0_24_11_2 Node0_24_11 Node0_25_11 76.99999999999991
R_0_24_11_3 Node0_24_11 Node1_24_11 3153.9199999999973
I_0_24_12 GND Node0_24_12 4.119442000000005e-05A
R_0_24_12_1 Node0_24_12 Node0_24_13 76.99999999999991
R_0_24_12_2 Node0_24_12 Node0_25_12 76.99999999999991
R_0_24_12_3 Node0_24_12 Node1_24_12 3153.9199999999973
I_0_24_13 GND Node0_24_13 4.140306000000005e-05A
R_0_24_13_1 Node0_24_13 Node0_24_14 77.0
R_0_24_13_2 Node0_24_13 Node0_25_13 76.99999999999991
R_0_24_13_3 Node0_24_13 Node1_24_13 3153.9199999999973
I_0_24_14 GND Node0_24_14 4.1619049999999965e-05A
R_0_24_14_1 Node0_24_14 Node0_24_15 77.0
R_0_24_14_2 Node0_24_14 Node0_25_14 77.00000000000007
R_0_24_14_3 Node0_24_14 Node1_24_14 3153.9200000000033
I_0_24_15 GND Node0_24_15 4.178503000000005e-05A
R_0_24_15_1 Node0_24_15 Node0_24_16 76.99999999999991
R_0_24_15_2 Node0_24_15 Node0_25_15 76.99999999999991
R_0_24_15_3 Node0_24_15 Node1_24_15 3153.9199999999973
I_0_24_16 GND Node0_24_16 4.1847630000000045e-05A
R_0_24_16_1 Node0_24_16 Node0_24_17 76.99999999999991
R_0_24_16_2 Node0_24_16 Node0_25_16 76.99999999999991
R_0_24_16_3 Node0_24_16 Node1_24_16 3153.9199999999973
I_0_24_17 GND Node0_24_17 4.178503000000005e-05A
R_0_24_17_1 Node0_24_17 Node0_24_18 76.99999999999991
R_0_24_17_2 Node0_24_17 Node0_25_17 76.99999999999991
R_0_24_17_3 Node0_24_17 Node1_24_17 3153.9199999999973
I_0_24_18 GND Node0_24_18 4.161905000000005e-05A
R_0_24_18_1 Node0_24_18 Node0_24_19 76.99999999999991
R_0_24_18_2 Node0_24_18 Node0_25_18 76.99999999999991
R_0_24_18_3 Node0_24_18 Node1_24_18 3153.9199999999973
I_0_24_19 GND Node0_24_19 4.140306000000005e-05A
R_0_24_19_1 Node0_24_19 Node0_24_20 76.99999999999991
R_0_24_19_2 Node0_24_19 Node0_25_19 76.99999999999991
R_0_24_19_3 Node0_24_19 Node1_24_19 3153.9199999999973
I_0_24_20 GND Node0_24_20 4.119442000000005e-05A
R_0_24_20_1 Node0_24_20 Node0_24_21 77.00000000000006
R_0_24_20_2 Node0_24_20 Node0_25_20 76.99999999999991
R_0_24_20_3 Node0_24_20 Node1_24_20 3153.9199999999973
I_0_24_21 GND Node0_24_21 4.10308699999999e-05A
R_0_24_21_1 Node0_24_21 Node0_24_22 77.00000000000006
R_0_24_21_2 Node0_24_21 Node0_25_21 77.00000000000018
R_0_24_21_3 Node0_24_21 Node1_24_21 3153.9200000000087
I_0_24_22 GND Node0_24_22 4.092318000000005e-05A
R_0_24_22_1 Node0_24_22 Node0_24_23 76.99999999999991
R_0_24_22_2 Node0_24_22 Node0_25_22 76.99999999999991
R_0_24_22_3 Node0_24_22 Node1_24_22 3153.9199999999973
I_0_24_23 GND Node0_24_23 4.0862590000000044e-05A
R_0_24_23_1 Node0_24_23 Node0_24_24 76.99999999999991
R_0_24_23_2 Node0_24_23 Node0_25_23 76.99999999999991
R_0_24_23_3 Node0_24_23 Node1_24_23 3153.9199999999973
I_0_24_24 GND Node0_24_24 4.083319000000005e-05A
R_0_24_24_1 Node0_24_24 Node0_24_25 76.99999999999991
R_0_24_24_2 Node0_24_24 Node0_25_24 76.99999999999991
R_0_24_24_3 Node0_24_24 Node1_24_24 3153.9199999999973
I_0_24_25 GND Node0_24_25 4.082080000000005e-05A
R_0_24_25_1 Node0_24_25 Node0_24_26 76.99999999999991
R_0_24_25_2 Node0_24_25 Node0_25_25 76.99999999999991
R_0_24_25_3 Node0_24_25 Node1_24_25 3153.9199999999973
I_0_24_26 GND Node0_24_26 4.081626000000004e-05A
R_0_24_26_1 Node0_24_26 Node0_24_27 76.99999999999991
R_0_24_26_2 Node0_24_26 Node0_25_26 76.99999999999991
R_0_24_26_3 Node0_24_26 Node1_24_26 3153.9199999999973
I_0_24_27 GND Node0_24_27 4.081480000000005e-05A
R_0_24_27_1 Node0_24_27 Node0_24_28 76.99999999999991
R_0_24_27_2 Node0_24_27 Node0_25_27 76.99999999999991
R_0_24_27_3 Node0_24_27 Node1_24_27 3153.9199999999973
I_0_24_28 GND Node0_24_28 4.081439000000005e-05A
R_0_24_28_1 Node0_24_28 Node0_24_29 77.00000000000006
R_0_24_28_2 Node0_24_28 Node0_25_28 76.99999999999991
R_0_24_28_3 Node0_24_28 Node1_24_28 3153.9199999999973
I_0_24_29 GND Node0_24_29 4.08142899999999e-05A
R_0_24_29_1 Node0_24_29 Node0_24_30 77.00000000000006
R_0_24_29_2 Node0_24_29 Node0_25_29 77.00000000000018
R_0_24_29_3 Node0_24_29 Node1_24_29 3153.9200000000087
I_0_24_30 GND Node0_24_30 4.0814270000000045e-05A
R_0_24_30_1 Node0_24_30 Node0_24_31 76.99999999999991
R_0_24_30_2 Node0_24_30 Node0_25_30 76.99999999999991
R_0_24_30_3 Node0_24_30 Node1_24_30 3153.9199999999973
I_0_24_31 GND Node0_24_31 4.0814260000000044e-05A
R_0_24_31_2 Node0_24_31 Node0_25_31 76.99999999999991
R_0_24_31_3 Node0_24_31 Node1_24_31 3153.9199999999973
I_0_25_0 GND Node0_25_0 4.081426e-05A
R_0_25_0_1 Node0_25_0 Node0_25_1 77.0
R_0_25_0_2 Node0_25_0 Node0_26_0 77.0
R_0_25_0_3 Node0_25_0 Node1_25_0 3153.9200000000005
I_0_25_1 GND Node0_25_1 4.081426e-05A
R_0_25_1_1 Node0_25_1 Node0_25_2 77.0
R_0_25_1_2 Node0_25_1 Node0_26_1 77.0
R_0_25_1_3 Node0_25_1 Node1_25_1 3153.9200000000005
I_0_25_2 GND Node0_25_2 4.081426e-05A
R_0_25_2_1 Node0_25_2 Node0_25_3 77.0
R_0_25_2_2 Node0_25_2 Node0_26_2 77.0
R_0_25_2_3 Node0_25_2 Node1_25_2 3153.9200000000005
I_0_25_3 GND Node0_25_3 4.081427e-05A
R_0_25_3_1 Node0_25_3 Node0_25_4 77.0
R_0_25_3_2 Node0_25_3 Node0_26_3 77.0
R_0_25_3_3 Node0_25_3 Node1_25_3 3153.9200000000005
I_0_25_4 GND Node0_25_4 4.08143e-05A
R_0_25_4_1 Node0_25_4 Node0_25_5 77.0
R_0_25_4_2 Node0_25_4 Node0_26_4 77.0
R_0_25_4_3 Node0_25_4 Node1_25_4 3153.9200000000005
I_0_25_5 GND Node0_25_5 4.081443e-05A
R_0_25_5_1 Node0_25_5 Node0_25_6 77.0
R_0_25_5_2 Node0_25_5 Node0_26_5 77.0
R_0_25_5_3 Node0_25_5 Node1_25_5 3153.9200000000005
I_0_25_6 GND Node0_25_6 4.081487e-05A
R_0_25_6_1 Node0_25_6 Node0_25_7 77.0
R_0_25_6_2 Node0_25_6 Node0_26_6 77.0
R_0_25_6_3 Node0_25_6 Node1_25_6 3153.9200000000005
I_0_25_7 GND Node0_25_7 4.0816259999999995e-05A
R_0_25_7_1 Node0_25_7 Node0_25_8 76.99999999999996
R_0_25_7_2 Node0_25_7 Node0_26_7 77.0
R_0_25_7_3 Node0_25_7 Node1_25_7 3153.9200000000005
I_0_25_8 GND Node0_25_8 4.082004000000005e-05A
R_0_25_8_1 Node0_25_8 Node0_25_9 76.99999999999991
R_0_25_8_2 Node0_25_8 Node0_26_8 76.99999999999991
R_0_25_8_3 Node0_25_8 Node1_25_8 3153.9199999999973
I_0_25_9 GND Node0_25_9 4.0829000000000046e-05A
R_0_25_9_1 Node0_25_9 Node0_25_10 77.0
R_0_25_9_2 Node0_25_9 Node0_26_9 76.99999999999991
R_0_25_9_3 Node0_25_9 Node1_25_9 3153.9199999999973
I_0_25_10 GND Node0_25_10 4.084747999999996e-05A
R_0_25_10_1 Node0_25_10 Node0_25_11 77.0
R_0_25_10_2 Node0_25_10 Node0_26_10 77.00000000000007
R_0_25_10_3 Node0_25_10 Node1_25_10 3153.9200000000033
I_0_25_11 GND Node0_25_11 4.0880320000000044e-05A
R_0_25_11_1 Node0_25_11 Node0_25_12 76.99999999999991
R_0_25_11_2 Node0_25_11 Node0_26_11 76.99999999999991
R_0_25_11_3 Node0_25_11 Node1_25_11 3153.9199999999973
I_0_25_12 GND Node0_25_12 4.093020000000005e-05A
R_0_25_12_1 Node0_25_12 Node0_25_13 76.99999999999991
R_0_25_12_2 Node0_25_12 Node0_26_12 76.99999999999991
R_0_25_12_3 Node0_25_12 Node1_25_12 3153.9199999999973
I_0_25_13 GND Node0_25_13 4.099384000000005e-05A
R_0_25_13_1 Node0_25_13 Node0_25_14 77.0
R_0_25_13_2 Node0_25_13 Node0_26_13 76.99999999999991
R_0_25_13_3 Node0_25_13 Node1_25_13 3153.9199999999973
I_0_25_14 GND Node0_25_14 4.105970999999997e-05A
R_0_25_14_1 Node0_25_14 Node0_25_15 77.0
R_0_25_14_2 Node0_25_14 Node0_26_14 77.00000000000007
R_0_25_14_3 Node0_25_14 Node1_25_14 3153.9200000000033
I_0_25_15 GND Node0_25_15 4.111033000000005e-05A
R_0_25_15_1 Node0_25_15 Node0_25_16 76.99999999999991
R_0_25_15_2 Node0_25_15 Node0_26_15 76.99999999999991
R_0_25_15_3 Node0_25_15 Node1_25_15 3153.9199999999973
I_0_25_16 GND Node0_25_16 4.112942000000005e-05A
R_0_25_16_1 Node0_25_16 Node0_25_17 76.99999999999991
R_0_25_16_2 Node0_25_16 Node0_26_16 76.99999999999991
R_0_25_16_3 Node0_25_16 Node1_25_16 3153.9199999999973
I_0_25_17 GND Node0_25_17 4.111033000000005e-05A
R_0_25_17_1 Node0_25_17 Node0_25_18 76.99999999999991
R_0_25_17_2 Node0_25_17 Node0_26_17 76.99999999999991
R_0_25_17_3 Node0_25_17 Node1_25_17 3153.9199999999973
I_0_25_18 GND Node0_25_18 4.105971000000005e-05A
R_0_25_18_1 Node0_25_18 Node0_25_19 76.99999999999991
R_0_25_18_2 Node0_25_18 Node0_26_18 76.99999999999991
R_0_25_18_3 Node0_25_18 Node1_25_18 3153.9199999999973
I_0_25_19 GND Node0_25_19 4.099384000000005e-05A
R_0_25_19_1 Node0_25_19 Node0_25_20 76.99999999999991
R_0_25_19_2 Node0_25_19 Node0_26_19 76.99999999999991
R_0_25_19_3 Node0_25_19 Node1_25_19 3153.9199999999973
I_0_25_20 GND Node0_25_20 4.093020000000005e-05A
R_0_25_20_1 Node0_25_20 Node0_25_21 77.00000000000006
R_0_25_20_2 Node0_25_20 Node0_26_20 76.99999999999991
R_0_25_20_3 Node0_25_20 Node1_25_20 3153.9199999999973
I_0_25_21 GND Node0_25_21 4.0880319999999895e-05A
R_0_25_21_1 Node0_25_21 Node0_25_22 77.00000000000006
R_0_25_21_2 Node0_25_21 Node0_26_21 77.00000000000018
R_0_25_21_3 Node0_25_21 Node1_25_21 3153.9200000000087
I_0_25_22 GND Node0_25_22 4.0847480000000044e-05A
R_0_25_22_1 Node0_25_22 Node0_25_23 76.99999999999991
R_0_25_22_2 Node0_25_22 Node0_26_22 76.99999999999991
R_0_25_22_3 Node0_25_22 Node1_25_22 3153.9199999999973
I_0_25_23 GND Node0_25_23 4.0829000000000046e-05A
R_0_25_23_1 Node0_25_23 Node0_25_24 76.99999999999991
R_0_25_23_2 Node0_25_23 Node0_26_23 76.99999999999991
R_0_25_23_3 Node0_25_23 Node1_25_23 3153.9199999999973
I_0_25_24 GND Node0_25_24 4.082004000000005e-05A
R_0_25_24_1 Node0_25_24 Node0_25_25 76.99999999999991
R_0_25_24_2 Node0_25_24 Node0_26_24 76.99999999999991
R_0_25_24_3 Node0_25_24 Node1_25_24 3153.9199999999973
I_0_25_25 GND Node0_25_25 4.081626000000004e-05A
R_0_25_25_1 Node0_25_25 Node0_25_26 76.99999999999991
R_0_25_25_2 Node0_25_25 Node0_26_25 76.99999999999991
R_0_25_25_3 Node0_25_25 Node1_25_25 3153.9199999999973
I_0_25_26 GND Node0_25_26 4.0814870000000047e-05A
R_0_25_26_1 Node0_25_26 Node0_25_27 76.99999999999991
R_0_25_26_2 Node0_25_26 Node0_26_26 76.99999999999991
R_0_25_26_3 Node0_25_26 Node1_25_26 3153.9199999999973
I_0_25_27 GND Node0_25_27 4.081443000000005e-05A
R_0_25_27_1 Node0_25_27 Node0_25_28 76.99999999999991
R_0_25_27_2 Node0_25_27 Node0_26_27 76.99999999999991
R_0_25_27_3 Node0_25_27 Node1_25_27 3153.9199999999973
I_0_25_28 GND Node0_25_28 4.081430000000005e-05A
R_0_25_28_1 Node0_25_28 Node0_25_29 77.00000000000006
R_0_25_28_2 Node0_25_28 Node0_26_28 76.99999999999991
R_0_25_28_3 Node0_25_28 Node1_25_28 3153.9199999999973
I_0_25_29 GND Node0_25_29 4.0814269999999896e-05A
R_0_25_29_1 Node0_25_29 Node0_25_30 77.00000000000006
R_0_25_29_2 Node0_25_29 Node0_26_29 77.00000000000018
R_0_25_29_3 Node0_25_29 Node1_25_29 3153.9200000000087
I_0_25_30 GND Node0_25_30 4.0814260000000044e-05A
R_0_25_30_1 Node0_25_30 Node0_25_31 76.99999999999991
R_0_25_30_2 Node0_25_30 Node0_26_30 76.99999999999991
R_0_25_30_3 Node0_25_30 Node1_25_30 3153.9199999999973
I_0_25_31 GND Node0_25_31 4.0814260000000044e-05A
R_0_25_31_2 Node0_25_31 Node0_26_31 76.99999999999991
R_0_25_31_3 Node0_25_31 Node1_25_31 3153.9199999999973
I_0_26_0 GND Node0_26_0 4.081426e-05A
R_0_26_0_1 Node0_26_0 Node0_26_1 77.0
R_0_26_0_2 Node0_26_0 Node0_27_0 77.0
R_0_26_0_3 Node0_26_0 Node1_26_0 3153.9200000000005
I_0_26_1 GND Node0_26_1 4.081426e-05A
R_0_26_1_1 Node0_26_1 Node0_26_2 77.0
R_0_26_1_2 Node0_26_1 Node0_27_1 77.0
R_0_26_1_3 Node0_26_1 Node1_26_1 3153.9200000000005
I_0_26_2 GND Node0_26_2 4.081426e-05A
R_0_26_2_1 Node0_26_2 Node0_26_3 77.0
R_0_26_2_2 Node0_26_2 Node0_27_2 77.0
R_0_26_2_3 Node0_26_2 Node1_26_2 3153.9200000000005
I_0_26_3 GND Node0_26_3 4.081427e-05A
R_0_26_3_1 Node0_26_3 Node0_26_4 77.0
R_0_26_3_2 Node0_26_3 Node0_27_3 77.0
R_0_26_3_3 Node0_26_3 Node1_26_3 3153.9200000000005
I_0_26_4 GND Node0_26_4 4.081427e-05A
R_0_26_4_1 Node0_26_4 Node0_26_5 77.0
R_0_26_4_2 Node0_26_4 Node0_27_4 77.0
R_0_26_4_3 Node0_26_4 Node1_26_4 3153.9200000000005
I_0_26_5 GND Node0_26_5 4.0814309999999994e-05A
R_0_26_5_1 Node0_26_5 Node0_26_6 77.0
R_0_26_5_2 Node0_26_5 Node0_27_5 77.0
R_0_26_5_3 Node0_26_5 Node1_26_5 3153.9200000000005
I_0_26_6 GND Node0_26_6 4.081443e-05A
R_0_26_6_1 Node0_26_6 Node0_26_7 77.0
R_0_26_6_2 Node0_26_6 Node0_27_6 77.0
R_0_26_6_3 Node0_26_6 Node1_26_6 3153.9200000000005
I_0_26_7 GND Node0_26_7 4.08148e-05A
R_0_26_7_1 Node0_26_7 Node0_26_8 76.99999999999996
R_0_26_7_2 Node0_26_7 Node0_27_7 77.0
R_0_26_7_3 Node0_26_7 Node1_26_7 3153.9200000000005
I_0_26_8 GND Node0_26_8 4.0815820000000045e-05A
R_0_26_8_1 Node0_26_8 Node0_26_9 76.99999999999991
R_0_26_8_2 Node0_26_8 Node0_27_8 76.99999999999991
R_0_26_8_3 Node0_26_8 Node1_26_8 3153.9199999999973
I_0_26_9 GND Node0_26_9 4.0818230000000044e-05A
R_0_26_9_1 Node0_26_9 Node0_26_10 77.0
R_0_26_9_2 Node0_26_9 Node0_27_9 76.99999999999991
R_0_26_9_3 Node0_26_9 Node1_26_9 3153.9199999999973
I_0_26_10 GND Node0_26_10 4.0823199999999965e-05A
R_0_26_10_1 Node0_26_10 Node0_26_11 77.0
R_0_26_10_2 Node0_26_10 Node0_27_10 77.00000000000007
R_0_26_10_3 Node0_26_10 Node1_26_10 3153.9200000000033
I_0_26_11 GND Node0_26_11 4.083204000000004e-05A
R_0_26_11_1 Node0_26_11 Node0_26_12 76.99999999999991
R_0_26_11_2 Node0_26_11 Node0_27_11 76.99999999999991
R_0_26_11_3 Node0_26_11 Node1_26_11 3153.9199999999973
I_0_26_12 GND Node0_26_12 4.0845470000000046e-05A
R_0_26_12_1 Node0_26_12 Node0_26_13 76.99999999999991
R_0_26_12_2 Node0_26_12 Node0_27_12 76.99999999999991
R_0_26_12_3 Node0_26_12 Node1_26_12 3153.9199999999973
I_0_26_13 GND Node0_26_13 4.0862590000000044e-05A
R_0_26_13_1 Node0_26_13 Node0_26_14 77.0
R_0_26_13_2 Node0_26_13 Node0_27_13 76.99999999999991
R_0_26_13_3 Node0_26_13 Node1_26_13 3153.9199999999973
I_0_26_14 GND Node0_26_14 4.088031999999996e-05A
R_0_26_14_1 Node0_26_14 Node0_26_15 77.0
R_0_26_14_2 Node0_26_14 Node0_27_14 77.00000000000007
R_0_26_14_3 Node0_26_14 Node1_26_14 3153.9200000000033
I_0_26_15 GND Node0_26_15 4.089395000000005e-05A
R_0_26_15_1 Node0_26_15 Node0_26_16 76.99999999999991
R_0_26_15_2 Node0_26_15 Node0_27_15 76.99999999999991
R_0_26_15_3 Node0_26_15 Node1_26_15 3153.9199999999973
I_0_26_16 GND Node0_26_16 4.089909000000005e-05A
R_0_26_16_1 Node0_26_16 Node0_26_17 76.99999999999991
R_0_26_16_2 Node0_26_16 Node0_27_16 76.99999999999991
R_0_26_16_3 Node0_26_16 Node1_26_16 3153.9199999999973
I_0_26_17 GND Node0_26_17 4.089395000000005e-05A
R_0_26_17_1 Node0_26_17 Node0_26_18 76.99999999999991
R_0_26_17_2 Node0_26_17 Node0_27_17 76.99999999999991
R_0_26_17_3 Node0_26_17 Node1_26_17 3153.9199999999973
I_0_26_18 GND Node0_26_18 4.0880320000000044e-05A
R_0_26_18_1 Node0_26_18 Node0_26_19 76.99999999999991
R_0_26_18_2 Node0_26_18 Node0_27_18 76.99999999999991
R_0_26_18_3 Node0_26_18 Node1_26_18 3153.9199999999973
I_0_26_19 GND Node0_26_19 4.0862590000000044e-05A
R_0_26_19_1 Node0_26_19 Node0_26_20 76.99999999999991
R_0_26_19_2 Node0_26_19 Node0_27_19 76.99999999999991
R_0_26_19_3 Node0_26_19 Node1_26_19 3153.9199999999973
I_0_26_20 GND Node0_26_20 4.0845470000000046e-05A
R_0_26_20_1 Node0_26_20 Node0_26_21 77.00000000000006
R_0_26_20_2 Node0_26_20 Node0_27_20 76.99999999999991
R_0_26_20_3 Node0_26_20 Node1_26_20 3153.9199999999973
I_0_26_21 GND Node0_26_21 4.083203999999989e-05A
R_0_26_21_1 Node0_26_21 Node0_26_22 77.00000000000006
R_0_26_21_2 Node0_26_21 Node0_27_21 77.00000000000018
R_0_26_21_3 Node0_26_21 Node1_26_21 3153.9200000000087
I_0_26_22 GND Node0_26_22 4.0823200000000046e-05A
R_0_26_22_1 Node0_26_22 Node0_26_23 76.99999999999991
R_0_26_22_2 Node0_26_22 Node0_27_22 76.99999999999991
R_0_26_22_3 Node0_26_22 Node1_26_22 3153.9199999999973
I_0_26_23 GND Node0_26_23 4.0818230000000044e-05A
R_0_26_23_1 Node0_26_23 Node0_26_24 76.99999999999991
R_0_26_23_2 Node0_26_23 Node0_27_23 76.99999999999991
R_0_26_23_3 Node0_26_23 Node1_26_23 3153.9199999999973
I_0_26_24 GND Node0_26_24 4.0815820000000045e-05A
R_0_26_24_1 Node0_26_24 Node0_26_25 76.99999999999991
R_0_26_24_2 Node0_26_24 Node0_27_24 76.99999999999991
R_0_26_24_3 Node0_26_24 Node1_26_24 3153.9199999999973
I_0_26_25 GND Node0_26_25 4.081480000000005e-05A
R_0_26_25_1 Node0_26_25 Node0_26_26 76.99999999999991
R_0_26_25_2 Node0_26_25 Node0_27_25 76.99999999999991
R_0_26_25_3 Node0_26_25 Node1_26_25 3153.9199999999973
I_0_26_26 GND Node0_26_26 4.081443000000005e-05A
R_0_26_26_1 Node0_26_26 Node0_26_27 76.99999999999991
R_0_26_26_2 Node0_26_26 Node0_27_26 76.99999999999991
R_0_26_26_3 Node0_26_26 Node1_26_26 3153.9199999999973
I_0_26_27 GND Node0_26_27 4.081431000000004e-05A
R_0_26_27_1 Node0_26_27 Node0_26_28 76.99999999999991
R_0_26_27_2 Node0_26_27 Node0_27_27 76.99999999999991
R_0_26_27_3 Node0_26_27 Node1_26_27 3153.9199999999973
I_0_26_28 GND Node0_26_28 4.0814270000000045e-05A
R_0_26_28_1 Node0_26_28 Node0_26_29 77.00000000000006
R_0_26_28_2 Node0_26_28 Node0_27_28 76.99999999999991
R_0_26_28_3 Node0_26_28 Node1_26_28 3153.9199999999973
I_0_26_29 GND Node0_26_29 4.0814269999999896e-05A
R_0_26_29_1 Node0_26_29 Node0_26_30 77.00000000000006
R_0_26_29_2 Node0_26_29 Node0_27_29 77.00000000000018
R_0_26_29_3 Node0_26_29 Node1_26_29 3153.9200000000087
I_0_26_30 GND Node0_26_30 4.0814260000000044e-05A
R_0_26_30_1 Node0_26_30 Node0_26_31 76.99999999999991
R_0_26_30_2 Node0_26_30 Node0_27_30 76.99999999999991
R_0_26_30_3 Node0_26_30 Node1_26_30 3153.9199999999973
I_0_26_31 GND Node0_26_31 4.0814260000000044e-05A
R_0_26_31_2 Node0_26_31 Node0_27_31 76.99999999999991
R_0_26_31_3 Node0_26_31 Node1_26_31 3153.9199999999973
I_0_27_0 GND Node0_27_0 4.081426e-05A
R_0_27_0_1 Node0_27_0 Node0_27_1 77.0
R_0_27_0_2 Node0_27_0 Node0_28_0 77.0
R_0_27_0_3 Node0_27_0 Node1_27_0 3153.9200000000005
I_0_27_1 GND Node0_27_1 4.081426e-05A
R_0_27_1_1 Node0_27_1 Node0_27_2 77.0
R_0_27_1_2 Node0_27_1 Node0_28_1 77.0
R_0_27_1_3 Node0_27_1 Node1_27_1 3153.9200000000005
I_0_27_2 GND Node0_27_2 4.081426e-05A
R_0_27_2_1 Node0_27_2 Node0_27_3 77.0
R_0_27_2_2 Node0_27_2 Node0_28_2 77.0
R_0_27_2_3 Node0_27_2 Node1_27_2 3153.9200000000005
I_0_27_3 GND Node0_27_3 4.081426e-05A
R_0_27_3_1 Node0_27_3 Node0_27_4 77.0
R_0_27_3_2 Node0_27_3 Node0_28_3 77.0
R_0_27_3_3 Node0_27_3 Node1_27_3 3153.9200000000005
I_0_27_4 GND Node0_27_4 4.081427e-05A
R_0_27_4_1 Node0_27_4 Node0_27_5 77.0
R_0_27_4_2 Node0_27_4 Node0_28_4 77.0
R_0_27_4_3 Node0_27_4 Node1_27_4 3153.9200000000005
I_0_27_5 GND Node0_27_5 4.081427e-05A
R_0_27_5_1 Node0_27_5 Node0_27_6 77.0
R_0_27_5_2 Node0_27_5 Node0_28_5 77.0
R_0_27_5_3 Node0_27_5 Node1_27_5 3153.9200000000005
I_0_27_6 GND Node0_27_6 4.08143e-05A
R_0_27_6_1 Node0_27_6 Node0_27_7 77.0
R_0_27_6_2 Node0_27_6 Node0_28_6 77.0
R_0_27_6_3 Node0_27_6 Node1_27_6 3153.9200000000005
I_0_27_7 GND Node0_27_7 4.081439e-05A
R_0_27_7_1 Node0_27_7 Node0_27_8 76.99999999999996
R_0_27_7_2 Node0_27_7 Node0_28_7 77.0
R_0_27_7_3 Node0_27_7 Node1_27_7 3153.9200000000005
I_0_27_8 GND Node0_27_8 4.081463000000004e-05A
R_0_27_8_1 Node0_27_8 Node0_27_9 76.99999999999991
R_0_27_8_2 Node0_27_8 Node0_28_8 76.99999999999991
R_0_27_8_3 Node0_27_8 Node1_27_8 3153.9199999999973
I_0_27_9 GND Node0_27_9 4.081521000000005e-05A
R_0_27_9_1 Node0_27_9 Node0_27_10 77.0
R_0_27_9_2 Node0_27_9 Node0_28_9 76.99999999999991
R_0_27_9_3 Node0_27_9 Node1_27_9 3153.9199999999973
I_0_27_10 GND Node0_27_10 4.081638999999996e-05A
R_0_27_10_1 Node0_27_10 Node0_27_11 77.0
R_0_27_10_2 Node0_27_10 Node0_28_10 77.00000000000007
R_0_27_10_3 Node0_27_10 Node1_27_10 3153.9200000000033
I_0_27_11 GND Node0_27_11 4.081849000000005e-05A
R_0_27_11_1 Node0_27_11 Node0_27_12 76.99999999999991
R_0_27_11_2 Node0_27_11 Node0_28_11 76.99999999999991
R_0_27_11_3 Node0_27_11 Node1_27_11 3153.9199999999973
I_0_27_12 GND Node0_27_12 4.082168000000005e-05A
R_0_27_12_1 Node0_27_12 Node0_27_13 76.99999999999991
R_0_27_12_2 Node0_27_12 Node0_28_12 76.99999999999991
R_0_27_12_3 Node0_27_12 Node1_27_12 3153.9199999999973
I_0_27_13 GND Node0_27_13 4.082574000000005e-05A
R_0_27_13_1 Node0_27_13 Node0_27_14 77.0
R_0_27_13_2 Node0_27_13 Node0_28_13 76.99999999999991
R_0_27_13_3 Node0_27_13 Node1_27_13 3153.9199999999973
I_0_27_14 GND Node0_27_14 4.082994999999996e-05A
R_0_27_14_1 Node0_27_14 Node0_27_15 77.0
R_0_27_14_2 Node0_27_14 Node0_28_14 77.00000000000007
R_0_27_14_3 Node0_27_14 Node1_27_14 3153.9200000000033
I_0_27_15 GND Node0_27_15 4.083319000000005e-05A
R_0_27_15_1 Node0_27_15 Node0_27_16 76.99999999999991
R_0_27_15_2 Node0_27_15 Node0_28_15 76.99999999999991
R_0_27_15_3 Node0_27_15 Node1_27_15 3153.9199999999973
I_0_27_16 GND Node0_27_16 4.0834410000000045e-05A
R_0_27_16_1 Node0_27_16 Node0_27_17 76.99999999999991
R_0_27_16_2 Node0_27_16 Node0_28_16 76.99999999999991
R_0_27_16_3 Node0_27_16 Node1_27_16 3153.9199999999973
I_0_27_17 GND Node0_27_17 4.083319000000005e-05A
R_0_27_17_1 Node0_27_17 Node0_27_18 76.99999999999991
R_0_27_17_2 Node0_27_17 Node0_28_17 76.99999999999991
R_0_27_17_3 Node0_27_17 Node1_27_17 3153.9199999999973
I_0_27_18 GND Node0_27_18 4.0829950000000044e-05A
R_0_27_18_1 Node0_27_18 Node0_27_19 76.99999999999991
R_0_27_18_2 Node0_27_18 Node0_28_18 76.99999999999991
R_0_27_18_3 Node0_27_18 Node1_27_18 3153.9199999999973
I_0_27_19 GND Node0_27_19 4.082574000000005e-05A
R_0_27_19_1 Node0_27_19 Node0_27_20 76.99999999999991
R_0_27_19_2 Node0_27_19 Node0_28_19 76.99999999999991
R_0_27_19_3 Node0_27_19 Node1_27_19 3153.9199999999973
I_0_27_20 GND Node0_27_20 4.082168000000005e-05A
R_0_27_20_1 Node0_27_20 Node0_27_21 77.00000000000006
R_0_27_20_2 Node0_27_20 Node0_28_20 76.99999999999991
R_0_27_20_3 Node0_27_20 Node1_27_20 3153.9199999999973
I_0_27_21 GND Node0_27_21 4.08184899999999e-05A
R_0_27_21_1 Node0_27_21 Node0_27_22 77.00000000000006
R_0_27_21_2 Node0_27_21 Node0_28_21 77.00000000000018
R_0_27_21_3 Node0_27_21 Node1_27_21 3153.9200000000087
I_0_27_22 GND Node0_27_22 4.0816390000000044e-05A
R_0_27_22_1 Node0_27_22 Node0_27_23 76.99999999999991
R_0_27_22_2 Node0_27_22 Node0_28_22 76.99999999999991
R_0_27_22_3 Node0_27_22 Node1_27_22 3153.9199999999973
I_0_27_23 GND Node0_27_23 4.081521000000005e-05A
R_0_27_23_1 Node0_27_23 Node0_27_24 76.99999999999991
R_0_27_23_2 Node0_27_23 Node0_28_23 76.99999999999991
R_0_27_23_3 Node0_27_23 Node1_27_23 3153.9199999999973
I_0_27_24 GND Node0_27_24 4.081463000000004e-05A
R_0_27_24_1 Node0_27_24 Node0_27_25 76.99999999999991
R_0_27_24_2 Node0_27_24 Node0_28_24 76.99999999999991
R_0_27_24_3 Node0_27_24 Node1_27_24 3153.9199999999973
I_0_27_25 GND Node0_27_25 4.081439000000005e-05A
R_0_27_25_1 Node0_27_25 Node0_27_26 76.99999999999991
R_0_27_25_2 Node0_27_25 Node0_28_25 76.99999999999991
R_0_27_25_3 Node0_27_25 Node1_27_25 3153.9199999999973
I_0_27_26 GND Node0_27_26 4.081430000000005e-05A
R_0_27_26_1 Node0_27_26 Node0_27_27 76.99999999999991
R_0_27_26_2 Node0_27_26 Node0_28_26 76.99999999999991
R_0_27_26_3 Node0_27_26 Node1_27_26 3153.9199999999973
I_0_27_27 GND Node0_27_27 4.0814270000000045e-05A
R_0_27_27_1 Node0_27_27 Node0_27_28 76.99999999999991
R_0_27_27_2 Node0_27_27 Node0_28_27 76.99999999999991
R_0_27_27_3 Node0_27_27 Node1_27_27 3153.9199999999973
I_0_27_28 GND Node0_27_28 4.0814270000000045e-05A
R_0_27_28_1 Node0_27_28 Node0_27_29 77.00000000000006
R_0_27_28_2 Node0_27_28 Node0_28_28 76.99999999999991
R_0_27_28_3 Node0_27_28 Node1_27_28 3153.9199999999973
I_0_27_29 GND Node0_27_29 4.0814259999999895e-05A
R_0_27_29_1 Node0_27_29 Node0_27_30 77.00000000000006
R_0_27_29_2 Node0_27_29 Node0_28_29 77.00000000000018
R_0_27_29_3 Node0_27_29 Node1_27_29 3153.9200000000087
I_0_27_30 GND Node0_27_30 4.0814260000000044e-05A
R_0_27_30_1 Node0_27_30 Node0_27_31 76.99999999999991
R_0_27_30_2 Node0_27_30 Node0_28_30 76.99999999999991
R_0_27_30_3 Node0_27_30 Node1_27_30 3153.9199999999973
I_0_27_31 GND Node0_27_31 4.0814260000000044e-05A
R_0_27_31_2 Node0_27_31 Node0_28_31 76.99999999999991
R_0_27_31_3 Node0_27_31 Node1_27_31 3153.9199999999973
I_0_28_0 GND Node0_28_0 4.081426e-05A
R_0_28_0_1 Node0_28_0 Node0_28_1 77.0
R_0_28_0_2 Node0_28_0 Node0_29_0 77.0
R_0_28_0_3 Node0_28_0 Node1_28_0 3153.9200000000005
I_0_28_1 GND Node0_28_1 4.081426e-05A
R_0_28_1_1 Node0_28_1 Node0_28_2 77.0
R_0_28_1_2 Node0_28_1 Node0_29_1 77.0
R_0_28_1_3 Node0_28_1 Node1_28_1 3153.9200000000005
I_0_28_2 GND Node0_28_2 4.081426e-05A
R_0_28_2_1 Node0_28_2 Node0_28_3 77.0
R_0_28_2_2 Node0_28_2 Node0_29_2 77.0
R_0_28_2_3 Node0_28_2 Node1_28_2 3153.9200000000005
I_0_28_3 GND Node0_28_3 4.081426e-05A
R_0_28_3_1 Node0_28_3 Node0_28_4 77.0
R_0_28_3_2 Node0_28_3 Node0_29_3 77.0
R_0_28_3_3 Node0_28_3 Node1_28_3 3153.9200000000005
I_0_28_4 GND Node0_28_4 4.081426e-05A
R_0_28_4_1 Node0_28_4 Node0_28_5 77.0
R_0_28_4_2 Node0_28_4 Node0_29_4 77.0
R_0_28_4_3 Node0_28_4 Node1_28_4 3153.9200000000005
I_0_28_5 GND Node0_28_5 4.081427e-05A
R_0_28_5_1 Node0_28_5 Node0_28_6 77.0
R_0_28_5_2 Node0_28_5 Node0_29_5 77.0
R_0_28_5_3 Node0_28_5 Node1_28_5 3153.9200000000005
I_0_28_6 GND Node0_28_6 4.081427e-05A
R_0_28_6_1 Node0_28_6 Node0_28_7 77.0
R_0_28_6_2 Node0_28_6 Node0_29_6 77.0
R_0_28_6_3 Node0_28_6 Node1_28_6 3153.9200000000005
I_0_28_7 GND Node0_28_7 4.081429e-05A
R_0_28_7_1 Node0_28_7 Node0_28_8 76.99999999999996
R_0_28_7_2 Node0_28_7 Node0_29_7 77.0
R_0_28_7_3 Node0_28_7 Node1_28_7 3153.9200000000005
I_0_28_8 GND Node0_28_8 4.081434000000005e-05A
R_0_28_8_1 Node0_28_8 Node0_28_9 76.99999999999991
R_0_28_8_2 Node0_28_8 Node0_29_8 76.99999999999991
R_0_28_8_3 Node0_28_8 Node1_28_8 3153.9199999999973
I_0_28_9 GND Node0_28_9 4.0814460000000045e-05A
R_0_28_9_1 Node0_28_9 Node0_28_10 77.0
R_0_28_9_2 Node0_28_9 Node0_29_9 76.99999999999991
R_0_28_9_3 Node0_28_9 Node1_28_9 3153.9199999999973
I_0_28_10 GND Node0_28_10 4.081470999999997e-05A
R_0_28_10_1 Node0_28_10 Node0_28_11 77.0
R_0_28_10_2 Node0_28_10 Node0_29_10 77.00000000000007
R_0_28_10_3 Node0_28_10 Node1_28_10 3153.9200000000033
I_0_28_11 GND Node0_28_11 4.0815150000000046e-05A
R_0_28_11_1 Node0_28_11 Node0_28_12 76.99999999999991
R_0_28_11_2 Node0_28_11 Node0_29_11 76.99999999999991
R_0_28_11_3 Node0_28_11 Node1_28_11 3153.9199999999973
I_0_28_12 GND Node0_28_12 4.0815820000000045e-05A
R_0_28_12_1 Node0_28_12 Node0_28_13 76.99999999999991
R_0_28_12_2 Node0_28_12 Node0_29_12 76.99999999999991
R_0_28_12_3 Node0_28_12 Node1_28_12 3153.9199999999973
I_0_28_13 GND Node0_28_13 4.081667000000005e-05A
R_0_28_13_1 Node0_28_13 Node0_28_14 77.0
R_0_28_13_2 Node0_28_13 Node0_29_13 76.99999999999991
R_0_28_13_3 Node0_28_13 Node1_28_13 3153.9199999999973
I_0_28_14 GND Node0_28_14 4.081754999999996e-05A
R_0_28_14_1 Node0_28_14 Node0_28_15 77.0
R_0_28_14_2 Node0_28_14 Node0_29_14 77.00000000000007
R_0_28_14_3 Node0_28_14 Node1_28_14 3153.9200000000033
I_0_28_15 GND Node0_28_15 4.0818230000000044e-05A
R_0_28_15_1 Node0_28_15 Node0_28_16 76.99999999999991
R_0_28_15_2 Node0_28_15 Node0_29_15 76.99999999999991
R_0_28_15_3 Node0_28_15 Node1_28_15 3153.9199999999973
I_0_28_16 GND Node0_28_16 4.081849000000005e-05A
R_0_28_16_1 Node0_28_16 Node0_28_17 76.99999999999991
R_0_28_16_2 Node0_28_16 Node0_29_16 76.99999999999991
R_0_28_16_3 Node0_28_16 Node1_28_16 3153.9199999999973
I_0_28_17 GND Node0_28_17 4.0818230000000044e-05A
R_0_28_17_1 Node0_28_17 Node0_28_18 76.99999999999991
R_0_28_17_2 Node0_28_17 Node0_29_17 76.99999999999991
R_0_28_17_3 Node0_28_17 Node1_28_17 3153.9199999999973
I_0_28_18 GND Node0_28_18 4.0817550000000044e-05A
R_0_28_18_1 Node0_28_18 Node0_28_19 76.99999999999991
R_0_28_18_2 Node0_28_18 Node0_29_18 76.99999999999991
R_0_28_18_3 Node0_28_18 Node1_28_18 3153.9199999999973
I_0_28_19 GND Node0_28_19 4.081667000000005e-05A
R_0_28_19_1 Node0_28_19 Node0_28_20 76.99999999999991
R_0_28_19_2 Node0_28_19 Node0_29_19 76.99999999999991
R_0_28_19_3 Node0_28_19 Node1_28_19 3153.9199999999973
I_0_28_20 GND Node0_28_20 4.0815820000000045e-05A
R_0_28_20_1 Node0_28_20 Node0_28_21 77.00000000000006
R_0_28_20_2 Node0_28_20 Node0_29_20 76.99999999999991
R_0_28_20_3 Node0_28_20 Node1_28_20 3153.9199999999973
I_0_28_21 GND Node0_28_21 4.08151499999999e-05A
R_0_28_21_1 Node0_28_21 Node0_28_22 77.00000000000006
R_0_28_21_2 Node0_28_21 Node0_29_21 77.00000000000018
R_0_28_21_3 Node0_28_21 Node1_28_21 3153.9200000000087
I_0_28_22 GND Node0_28_22 4.081471000000005e-05A
R_0_28_22_1 Node0_28_22 Node0_28_23 76.99999999999991
R_0_28_22_2 Node0_28_22 Node0_29_22 76.99999999999991
R_0_28_22_3 Node0_28_22 Node1_28_22 3153.9199999999973
I_0_28_23 GND Node0_28_23 4.0814460000000045e-05A
R_0_28_23_1 Node0_28_23 Node0_28_24 76.99999999999991
R_0_28_23_2 Node0_28_23 Node0_29_23 76.99999999999991
R_0_28_23_3 Node0_28_23 Node1_28_23 3153.9199999999973
I_0_28_24 GND Node0_28_24 4.081434000000005e-05A
R_0_28_24_1 Node0_28_24 Node0_28_25 76.99999999999991
R_0_28_24_2 Node0_28_24 Node0_29_24 76.99999999999991
R_0_28_24_3 Node0_28_24 Node1_28_24 3153.9199999999973
I_0_28_25 GND Node0_28_25 4.0814290000000047e-05A
R_0_28_25_1 Node0_28_25 Node0_28_26 76.99999999999991
R_0_28_25_2 Node0_28_25 Node0_29_25 76.99999999999991
R_0_28_25_3 Node0_28_25 Node1_28_25 3153.9199999999973
I_0_28_26 GND Node0_28_26 4.0814270000000045e-05A
R_0_28_26_1 Node0_28_26 Node0_28_27 76.99999999999991
R_0_28_26_2 Node0_28_26 Node0_29_26 76.99999999999991
R_0_28_26_3 Node0_28_26 Node1_28_26 3153.9199999999973
I_0_28_27 GND Node0_28_27 4.0814270000000045e-05A
R_0_28_27_1 Node0_28_27 Node0_28_28 76.99999999999991
R_0_28_27_2 Node0_28_27 Node0_29_27 76.99999999999991
R_0_28_27_3 Node0_28_27 Node1_28_27 3153.9199999999973
I_0_28_28 GND Node0_28_28 4.0814260000000044e-05A
R_0_28_28_1 Node0_28_28 Node0_28_29 77.00000000000006
R_0_28_28_2 Node0_28_28 Node0_29_28 76.99999999999991
R_0_28_28_3 Node0_28_28 Node1_28_28 3153.9199999999973
I_0_28_29 GND Node0_28_29 4.0814259999999895e-05A
R_0_28_29_1 Node0_28_29 Node0_28_30 77.00000000000006
R_0_28_29_2 Node0_28_29 Node0_29_29 77.00000000000018
R_0_28_29_3 Node0_28_29 Node1_28_29 3153.9200000000087
I_0_28_30 GND Node0_28_30 4.0814260000000044e-05A
R_0_28_30_1 Node0_28_30 Node0_28_31 76.99999999999991
R_0_28_30_2 Node0_28_30 Node0_29_30 76.99999999999991
R_0_28_30_3 Node0_28_30 Node1_28_30 3153.9199999999973
I_0_28_31 GND Node0_28_31 4.0814260000000044e-05A
R_0_28_31_2 Node0_28_31 Node0_29_31 76.99999999999991
R_0_28_31_3 Node0_28_31 Node1_28_31 3153.9199999999973
I_0_29_0 GND Node0_29_0 4.081426e-05A
R_0_29_0_1 Node0_29_0 Node0_29_1 77.0
R_0_29_0_2 Node0_29_0 Node0_30_0 77.0
R_0_29_0_3 Node0_29_0 Node1_29_0 3153.9200000000005
I_0_29_1 GND Node0_29_1 4.081426e-05A
R_0_29_1_1 Node0_29_1 Node0_29_2 77.0
R_0_29_1_2 Node0_29_1 Node0_30_1 77.0
R_0_29_1_3 Node0_29_1 Node1_29_1 3153.9200000000005
I_0_29_2 GND Node0_29_2 4.081426e-05A
R_0_29_2_1 Node0_29_2 Node0_29_3 77.0
R_0_29_2_2 Node0_29_2 Node0_30_2 77.0
R_0_29_2_3 Node0_29_2 Node1_29_2 3153.9200000000005
I_0_29_3 GND Node0_29_3 4.081426e-05A
R_0_29_3_1 Node0_29_3 Node0_29_4 77.0
R_0_29_3_2 Node0_29_3 Node0_30_3 77.0
R_0_29_3_3 Node0_29_3 Node1_29_3 3153.9200000000005
I_0_29_4 GND Node0_29_4 4.081426e-05A
R_0_29_4_1 Node0_29_4 Node0_29_5 77.0
R_0_29_4_2 Node0_29_4 Node0_30_4 77.0
R_0_29_4_3 Node0_29_4 Node1_29_4 3153.9200000000005
I_0_29_5 GND Node0_29_5 4.081426e-05A
R_0_29_5_1 Node0_29_5 Node0_29_6 77.0
R_0_29_5_2 Node0_29_5 Node0_30_5 77.0
R_0_29_5_3 Node0_29_5 Node1_29_5 3153.9200000000005
I_0_29_6 GND Node0_29_6 4.081426e-05A
R_0_29_6_1 Node0_29_6 Node0_29_7 77.0
R_0_29_6_2 Node0_29_6 Node0_30_6 77.0
R_0_29_6_3 Node0_29_6 Node1_29_6 3153.9200000000005
I_0_29_7 GND Node0_29_7 4.081427e-05A
R_0_29_7_1 Node0_29_7 Node0_29_8 76.99999999999996
R_0_29_7_2 Node0_29_7 Node0_30_7 77.0
R_0_29_7_3 Node0_29_7 Node1_29_7 3153.9200000000005
I_0_29_8 GND Node0_29_8 4.0814280000000046e-05A
R_0_29_8_1 Node0_29_8 Node0_29_9 76.99999999999991
R_0_29_8_2 Node0_29_8 Node0_30_8 76.99999999999991
R_0_29_8_3 Node0_29_8 Node1_29_8 3153.9199999999973
I_0_29_9 GND Node0_29_9 4.081430000000005e-05A
R_0_29_9_1 Node0_29_9 Node0_29_10 77.0
R_0_29_9_2 Node0_29_9 Node0_30_9 76.99999999999991
R_0_29_9_3 Node0_29_9 Node1_29_9 3153.9199999999973
I_0_29_10 GND Node0_29_10 4.081434999999997e-05A
R_0_29_10_1 Node0_29_10 Node0_29_11 77.0
R_0_29_10_2 Node0_29_10 Node0_30_10 77.00000000000007
R_0_29_10_3 Node0_29_10 Node1_29_10 3153.9200000000033
I_0_29_11 GND Node0_29_11 4.081443000000005e-05A
R_0_29_11_1 Node0_29_11 Node0_29_12 76.99999999999991
R_0_29_11_2 Node0_29_11 Node0_30_11 76.99999999999991
R_0_29_11_3 Node0_29_11 Node1_29_11 3153.9199999999973
I_0_29_12 GND Node0_29_12 4.0814550000000044e-05A
R_0_29_12_1 Node0_29_12 Node0_29_13 76.99999999999991
R_0_29_12_2 Node0_29_12 Node0_30_12 76.99999999999991
R_0_29_12_3 Node0_29_12 Node1_29_12 3153.9199999999973
I_0_29_13 GND Node0_29_13 4.081471000000005e-05A
R_0_29_13_1 Node0_29_13 Node0_29_14 77.0
R_0_29_13_2 Node0_29_13 Node0_30_13 76.99999999999991
R_0_29_13_3 Node0_29_13 Node1_29_13 3153.9199999999973
I_0_29_14 GND Node0_29_14 4.0814869999999965e-05A
R_0_29_14_1 Node0_29_14 Node0_29_15 77.0
R_0_29_14_2 Node0_29_14 Node0_30_14 77.00000000000007
R_0_29_14_3 Node0_29_14 Node1_29_14 3153.9200000000033
I_0_29_15 GND Node0_29_15 4.081500000000005e-05A
R_0_29_15_1 Node0_29_15 Node0_29_16 76.99999999999991
R_0_29_15_2 Node0_29_15 Node0_30_15 76.99999999999991
R_0_29_15_3 Node0_29_15 Node1_29_15 3153.9199999999973
I_0_29_16 GND Node0_29_16 4.0815040000000045e-05A
R_0_29_16_1 Node0_29_16 Node0_29_17 76.99999999999991
R_0_29_16_2 Node0_29_16 Node0_30_16 76.99999999999991
R_0_29_16_3 Node0_29_16 Node1_29_16 3153.9199999999973
I_0_29_17 GND Node0_29_17 4.081500000000005e-05A
R_0_29_17_1 Node0_29_17 Node0_29_18 76.99999999999991
R_0_29_17_2 Node0_29_17 Node0_30_17 76.99999999999991
R_0_29_17_3 Node0_29_17 Node1_29_17 3153.9199999999973
I_0_29_18 GND Node0_29_18 4.0814870000000047e-05A
R_0_29_18_1 Node0_29_18 Node0_29_19 76.99999999999991
R_0_29_18_2 Node0_29_18 Node0_30_18 76.99999999999991
R_0_29_18_3 Node0_29_18 Node1_29_18 3153.9199999999973
I_0_29_19 GND Node0_29_19 4.081471000000005e-05A
R_0_29_19_1 Node0_29_19 Node0_29_20 76.99999999999991
R_0_29_19_2 Node0_29_19 Node0_30_19 76.99999999999991
R_0_29_19_3 Node0_29_19 Node1_29_19 3153.9199999999973
I_0_29_20 GND Node0_29_20 4.0814550000000044e-05A
R_0_29_20_1 Node0_29_20 Node0_29_21 77.00000000000006
R_0_29_20_2 Node0_29_20 Node0_30_20 76.99999999999991
R_0_29_20_3 Node0_29_20 Node1_29_20 3153.9199999999973
I_0_29_21 GND Node0_29_21 4.08144299999999e-05A
R_0_29_21_1 Node0_29_21 Node0_29_22 77.00000000000006
R_0_29_21_2 Node0_29_21 Node0_30_21 77.00000000000018
R_0_29_21_3 Node0_29_21 Node1_29_21 3153.9200000000087
I_0_29_22 GND Node0_29_22 4.081435000000005e-05A
R_0_29_22_1 Node0_29_22 Node0_29_23 76.99999999999991
R_0_29_22_2 Node0_29_22 Node0_30_22 76.99999999999991
R_0_29_22_3 Node0_29_22 Node1_29_22 3153.9199999999973
I_0_29_23 GND Node0_29_23 4.081430000000005e-05A
R_0_29_23_1 Node0_29_23 Node0_29_24 76.99999999999991
R_0_29_23_2 Node0_29_23 Node0_30_23 76.99999999999991
R_0_29_23_3 Node0_29_23 Node1_29_23 3153.9199999999973
I_0_29_24 GND Node0_29_24 4.0814280000000046e-05A
R_0_29_24_1 Node0_29_24 Node0_29_25 76.99999999999991
R_0_29_24_2 Node0_29_24 Node0_30_24 76.99999999999991
R_0_29_24_3 Node0_29_24 Node1_29_24 3153.9199999999973
I_0_29_25 GND Node0_29_25 4.0814270000000045e-05A
R_0_29_25_1 Node0_29_25 Node0_29_26 76.99999999999991
R_0_29_25_2 Node0_29_25 Node0_30_25 76.99999999999991
R_0_29_25_3 Node0_29_25 Node1_29_25 3153.9199999999973
I_0_29_26 GND Node0_29_26 4.0814260000000044e-05A
R_0_29_26_1 Node0_29_26 Node0_29_27 76.99999999999991
R_0_29_26_2 Node0_29_26 Node0_30_26 76.99999999999991
R_0_29_26_3 Node0_29_26 Node1_29_26 3153.9199999999973
I_0_29_27 GND Node0_29_27 4.0814260000000044e-05A
R_0_29_27_1 Node0_29_27 Node0_29_28 76.99999999999991
R_0_29_27_2 Node0_29_27 Node0_30_27 76.99999999999991
R_0_29_27_3 Node0_29_27 Node1_29_27 3153.9199999999973
I_0_29_28 GND Node0_29_28 4.0814260000000044e-05A
R_0_29_28_1 Node0_29_28 Node0_29_29 77.00000000000006
R_0_29_28_2 Node0_29_28 Node0_30_28 76.99999999999991
R_0_29_28_3 Node0_29_28 Node1_29_28 3153.9199999999973
I_0_29_29 GND Node0_29_29 4.0814259999999895e-05A
R_0_29_29_1 Node0_29_29 Node0_29_30 77.00000000000006
R_0_29_29_2 Node0_29_29 Node0_30_29 77.00000000000018
R_0_29_29_3 Node0_29_29 Node1_29_29 3153.9200000000087
I_0_29_30 GND Node0_29_30 4.0814260000000044e-05A
R_0_29_30_1 Node0_29_30 Node0_29_31 76.99999999999991
R_0_29_30_2 Node0_29_30 Node0_30_30 76.99999999999991
R_0_29_30_3 Node0_29_30 Node1_29_30 3153.9199999999973
I_0_29_31 GND Node0_29_31 4.0814260000000044e-05A
R_0_29_31_2 Node0_29_31 Node0_30_31 76.99999999999991
R_0_29_31_3 Node0_29_31 Node1_29_31 3153.9199999999973
I_0_30_0 GND Node0_30_0 4.081426e-05A
R_0_30_0_1 Node0_30_0 Node0_30_1 77.0
R_0_30_0_2 Node0_30_0 Node0_31_0 77.0
R_0_30_0_3 Node0_30_0 Node1_30_0 3153.9200000000005
I_0_30_1 GND Node0_30_1 4.081426e-05A
R_0_30_1_1 Node0_30_1 Node0_30_2 77.0
R_0_30_1_2 Node0_30_1 Node0_31_1 77.0
R_0_30_1_3 Node0_30_1 Node1_30_1 3153.9200000000005
I_0_30_2 GND Node0_30_2 4.081426e-05A
R_0_30_2_1 Node0_30_2 Node0_30_3 77.0
R_0_30_2_2 Node0_30_2 Node0_31_2 77.0
R_0_30_2_3 Node0_30_2 Node1_30_2 3153.9200000000005
I_0_30_3 GND Node0_30_3 4.081426e-05A
R_0_30_3_1 Node0_30_3 Node0_30_4 77.0
R_0_30_3_2 Node0_30_3 Node0_31_3 77.0
R_0_30_3_3 Node0_30_3 Node1_30_3 3153.9200000000005
I_0_30_4 GND Node0_30_4 4.081426e-05A
R_0_30_4_1 Node0_30_4 Node0_30_5 77.0
R_0_30_4_2 Node0_30_4 Node0_31_4 77.0
R_0_30_4_3 Node0_30_4 Node1_30_4 3153.9200000000005
I_0_30_5 GND Node0_30_5 4.081426e-05A
R_0_30_5_1 Node0_30_5 Node0_30_6 77.0
R_0_30_5_2 Node0_30_5 Node0_31_5 77.0
R_0_30_5_3 Node0_30_5 Node1_30_5 3153.9200000000005
I_0_30_6 GND Node0_30_6 4.081426e-05A
R_0_30_6_1 Node0_30_6 Node0_30_7 77.0
R_0_30_6_2 Node0_30_6 Node0_31_6 77.0
R_0_30_6_3 Node0_30_6 Node1_30_6 3153.9200000000005
I_0_30_7 GND Node0_30_7 4.081426e-05A
R_0_30_7_1 Node0_30_7 Node0_30_8 76.99999999999996
R_0_30_7_2 Node0_30_7 Node0_31_7 77.0
R_0_30_7_3 Node0_30_7 Node1_30_7 3153.9200000000005
I_0_30_8 GND Node0_30_8 4.0814270000000045e-05A
R_0_30_8_1 Node0_30_8 Node0_30_9 76.99999999999991
R_0_30_8_2 Node0_30_8 Node0_31_8 76.99999999999991
R_0_30_8_3 Node0_30_8 Node1_30_8 3153.9199999999973
I_0_30_9 GND Node0_30_9 4.0814270000000045e-05A
R_0_30_9_1 Node0_30_9 Node0_30_10 77.0
R_0_30_9_2 Node0_30_9 Node0_31_9 76.99999999999991
R_0_30_9_3 Node0_30_9 Node1_30_9 3153.9199999999973
I_0_30_10 GND Node0_30_10 4.0814279999999965e-05A
R_0_30_10_1 Node0_30_10 Node0_30_11 77.0
R_0_30_10_2 Node0_30_10 Node0_31_10 77.00000000000007
R_0_30_10_3 Node0_30_10 Node1_30_10 3153.9200000000033
I_0_30_11 GND Node0_30_11 4.0814290000000047e-05A
R_0_30_11_1 Node0_30_11 Node0_30_12 76.99999999999991
R_0_30_11_2 Node0_30_11 Node0_31_11 76.99999999999991
R_0_30_11_3 Node0_30_11 Node1_30_11 3153.9199999999973
I_0_30_12 GND Node0_30_12 4.081431000000004e-05A
R_0_30_12_1 Node0_30_12 Node0_30_13 76.99999999999991
R_0_30_12_2 Node0_30_12 Node0_31_12 76.99999999999991
R_0_30_12_3 Node0_30_12 Node1_30_12 3153.9199999999973
I_0_30_13 GND Node0_30_13 4.081434000000005e-05A
R_0_30_13_1 Node0_30_13 Node0_30_14 77.0
R_0_30_13_2 Node0_30_13 Node0_31_13 76.99999999999991
R_0_30_13_3 Node0_30_13 Node1_30_13 3153.9199999999973
I_0_30_14 GND Node0_30_14 4.0814359999999963e-05A
R_0_30_14_1 Node0_30_14 Node0_30_15 77.0
R_0_30_14_2 Node0_30_14 Node0_31_14 77.00000000000007
R_0_30_14_3 Node0_30_14 Node1_30_14 3153.9200000000033
I_0_30_15 GND Node0_30_15 4.0814380000000046e-05A
R_0_30_15_1 Node0_30_15 Node0_30_16 76.99999999999991
R_0_30_15_2 Node0_30_15 Node0_31_15 76.99999999999991
R_0_30_15_3 Node0_30_15 Node1_30_15 3153.9199999999973
I_0_30_16 GND Node0_30_16 4.081439000000005e-05A
R_0_30_16_1 Node0_30_16 Node0_30_17 76.99999999999991
R_0_30_16_2 Node0_30_16 Node0_31_16 76.99999999999991
R_0_30_16_3 Node0_30_16 Node1_30_16 3153.9199999999973
I_0_30_17 GND Node0_30_17 4.0814380000000046e-05A
R_0_30_17_1 Node0_30_17 Node0_30_18 76.99999999999991
R_0_30_17_2 Node0_30_17 Node0_31_17 76.99999999999991
R_0_30_17_3 Node0_30_17 Node1_30_17 3153.9199999999973
I_0_30_18 GND Node0_30_18 4.0814360000000045e-05A
R_0_30_18_1 Node0_30_18 Node0_30_19 76.99999999999991
R_0_30_18_2 Node0_30_18 Node0_31_18 76.99999999999991
R_0_30_18_3 Node0_30_18 Node1_30_18 3153.9199999999973
I_0_30_19 GND Node0_30_19 4.081434000000005e-05A
R_0_30_19_1 Node0_30_19 Node0_30_20 76.99999999999991
R_0_30_19_2 Node0_30_19 Node0_31_19 76.99999999999991
R_0_30_19_3 Node0_30_19 Node1_30_19 3153.9199999999973
I_0_30_20 GND Node0_30_20 4.081431000000004e-05A
R_0_30_20_1 Node0_30_20 Node0_30_21 77.00000000000006
R_0_30_20_2 Node0_30_20 Node0_31_20 76.99999999999991
R_0_30_20_3 Node0_30_20 Node1_30_20 3153.9199999999973
I_0_30_21 GND Node0_30_21 4.08142899999999e-05A
R_0_30_21_1 Node0_30_21 Node0_30_22 77.00000000000006
R_0_30_21_2 Node0_30_21 Node0_31_21 77.00000000000018
R_0_30_21_3 Node0_30_21 Node1_30_21 3153.9200000000087
I_0_30_22 GND Node0_30_22 4.0814280000000046e-05A
R_0_30_22_1 Node0_30_22 Node0_30_23 76.99999999999991
R_0_30_22_2 Node0_30_22 Node0_31_22 76.99999999999991
R_0_30_22_3 Node0_30_22 Node1_30_22 3153.9199999999973
I_0_30_23 GND Node0_30_23 4.0814270000000045e-05A
R_0_30_23_1 Node0_30_23 Node0_30_24 76.99999999999991
R_0_30_23_2 Node0_30_23 Node0_31_23 76.99999999999991
R_0_30_23_3 Node0_30_23 Node1_30_23 3153.9199999999973
I_0_30_24 GND Node0_30_24 4.0814270000000045e-05A
R_0_30_24_1 Node0_30_24 Node0_30_25 76.99999999999991
R_0_30_24_2 Node0_30_24 Node0_31_24 76.99999999999991
R_0_30_24_3 Node0_30_24 Node1_30_24 3153.9199999999973
I_0_30_25 GND Node0_30_25 4.0814260000000044e-05A
R_0_30_25_1 Node0_30_25 Node0_30_26 76.99999999999991
R_0_30_25_2 Node0_30_25 Node0_31_25 76.99999999999991
R_0_30_25_3 Node0_30_25 Node1_30_25 3153.9199999999973
I_0_30_26 GND Node0_30_26 4.0814260000000044e-05A
R_0_30_26_1 Node0_30_26 Node0_30_27 76.99999999999991
R_0_30_26_2 Node0_30_26 Node0_31_26 76.99999999999991
R_0_30_26_3 Node0_30_26 Node1_30_26 3153.9199999999973
I_0_30_27 GND Node0_30_27 4.0814260000000044e-05A
R_0_30_27_1 Node0_30_27 Node0_30_28 76.99999999999991
R_0_30_27_2 Node0_30_27 Node0_31_27 76.99999999999991
R_0_30_27_3 Node0_30_27 Node1_30_27 3153.9199999999973
I_0_30_28 GND Node0_30_28 4.0814260000000044e-05A
R_0_30_28_1 Node0_30_28 Node0_30_29 77.00000000000006
R_0_30_28_2 Node0_30_28 Node0_31_28 76.99999999999991
R_0_30_28_3 Node0_30_28 Node1_30_28 3153.9199999999973
I_0_30_29 GND Node0_30_29 4.0814259999999895e-05A
R_0_30_29_1 Node0_30_29 Node0_30_30 77.00000000000006
R_0_30_29_2 Node0_30_29 Node0_31_29 77.00000000000018
R_0_30_29_3 Node0_30_29 Node1_30_29 3153.9200000000087
I_0_30_30 GND Node0_30_30 4.0814260000000044e-05A
R_0_30_30_1 Node0_30_30 Node0_30_31 76.99999999999991
R_0_30_30_2 Node0_30_30 Node0_31_30 76.99999999999991
R_0_30_30_3 Node0_30_30 Node1_30_30 3153.9199999999973
I_0_30_31 GND Node0_30_31 4.0814260000000044e-05A
R_0_30_31_2 Node0_30_31 Node0_31_31 76.99999999999991
R_0_30_31_3 Node0_30_31 Node1_30_31 3153.9199999999973
I_0_31_0 GND Node0_31_0 4.081426e-05A
R_0_31_0_1 Node0_31_0 Node0_31_1 77.0
R_0_31_0_3 Node0_31_0 Node1_31_0 3153.9200000000005
I_0_31_1 GND Node0_31_1 4.081426e-05A
R_0_31_1_1 Node0_31_1 Node0_31_2 77.0
R_0_31_1_3 Node0_31_1 Node1_31_1 3153.9200000000005
I_0_31_2 GND Node0_31_2 4.081426e-05A
R_0_31_2_1 Node0_31_2 Node0_31_3 77.0
R_0_31_2_3 Node0_31_2 Node1_31_2 3153.9200000000005
I_0_31_3 GND Node0_31_3 4.081426e-05A
R_0_31_3_1 Node0_31_3 Node0_31_4 77.0
R_0_31_3_3 Node0_31_3 Node1_31_3 3153.9200000000005
I_0_31_4 GND Node0_31_4 4.081426e-05A
R_0_31_4_1 Node0_31_4 Node0_31_5 77.0
R_0_31_4_3 Node0_31_4 Node1_31_4 3153.9200000000005
I_0_31_5 GND Node0_31_5 4.081426e-05A
R_0_31_5_1 Node0_31_5 Node0_31_6 77.0
R_0_31_5_3 Node0_31_5 Node1_31_5 3153.9200000000005
I_0_31_6 GND Node0_31_6 4.081426e-05A
R_0_31_6_1 Node0_31_6 Node0_31_7 77.0
R_0_31_6_3 Node0_31_6 Node1_31_6 3153.9200000000005
I_0_31_7 GND Node0_31_7 4.081426e-05A
R_0_31_7_1 Node0_31_7 Node0_31_8 76.99999999999996
R_0_31_7_3 Node0_31_7 Node1_31_7 3153.9200000000005
I_0_31_8 GND Node0_31_8 4.0814260000000044e-05A
R_0_31_8_1 Node0_31_8 Node0_31_9 76.99999999999991
R_0_31_8_3 Node0_31_8 Node1_31_8 3153.9199999999973
I_0_31_9 GND Node0_31_9 4.0814260000000044e-05A
R_0_31_9_1 Node0_31_9 Node0_31_10 77.0
R_0_31_9_3 Node0_31_9 Node1_31_9 3153.9199999999973
I_0_31_10 GND Node0_31_10 4.0814269999999964e-05A
R_0_31_10_1 Node0_31_10 Node0_31_11 77.0
R_0_31_10_3 Node0_31_10 Node1_31_10 3153.9200000000033
I_0_31_11 GND Node0_31_11 4.0814270000000045e-05A
R_0_31_11_1 Node0_31_11 Node0_31_12 76.99999999999991
R_0_31_11_3 Node0_31_11 Node1_31_11 3153.9199999999973
I_0_31_12 GND Node0_31_12 4.0814270000000045e-05A
R_0_31_12_1 Node0_31_12 Node0_31_13 76.99999999999991
R_0_31_12_3 Node0_31_12 Node1_31_12 3153.9199999999973
I_0_31_13 GND Node0_31_13 4.0814270000000045e-05A
R_0_31_13_1 Node0_31_13 Node0_31_14 77.0
R_0_31_13_3 Node0_31_13 Node1_31_13 3153.9199999999973
I_0_31_14 GND Node0_31_14 4.0814279999999965e-05A
R_0_31_14_1 Node0_31_14 Node0_31_15 77.0
R_0_31_14_3 Node0_31_14 Node1_31_14 3153.9200000000033
I_0_31_15 GND Node0_31_15 4.0814280000000046e-05A
R_0_31_15_1 Node0_31_15 Node0_31_16 76.99999999999991
R_0_31_15_3 Node0_31_15 Node1_31_15 3153.9199999999973
I_0_31_16 GND Node0_31_16 4.0814280000000046e-05A
R_0_31_16_1 Node0_31_16 Node0_31_17 76.99999999999991
R_0_31_16_3 Node0_31_16 Node1_31_16 3153.9199999999973
I_0_31_17 GND Node0_31_17 4.0814280000000046e-05A
R_0_31_17_1 Node0_31_17 Node0_31_18 76.99999999999991
R_0_31_17_3 Node0_31_17 Node1_31_17 3153.9199999999973
I_0_31_18 GND Node0_31_18 4.0814280000000046e-05A
R_0_31_18_1 Node0_31_18 Node0_31_19 76.99999999999991
R_0_31_18_3 Node0_31_18 Node1_31_18 3153.9199999999973
I_0_31_19 GND Node0_31_19 4.0814270000000045e-05A
R_0_31_19_1 Node0_31_19 Node0_31_20 76.99999999999991
R_0_31_19_3 Node0_31_19 Node1_31_19 3153.9199999999973
I_0_31_20 GND Node0_31_20 4.0814270000000045e-05A
R_0_31_20_1 Node0_31_20 Node0_31_21 77.00000000000006
R_0_31_20_3 Node0_31_20 Node1_31_20 3153.9199999999973
I_0_31_21 GND Node0_31_21 4.0814269999999896e-05A
R_0_31_21_1 Node0_31_21 Node0_31_22 77.00000000000006
R_0_31_21_3 Node0_31_21 Node1_31_21 3153.9200000000087
I_0_31_22 GND Node0_31_22 4.0814270000000045e-05A
R_0_31_22_1 Node0_31_22 Node0_31_23 76.99999999999991
R_0_31_22_3 Node0_31_22 Node1_31_22 3153.9199999999973
I_0_31_23 GND Node0_31_23 4.0814260000000044e-05A
R_0_31_23_1 Node0_31_23 Node0_31_24 76.99999999999991
R_0_31_23_3 Node0_31_23 Node1_31_23 3153.9199999999973
I_0_31_24 GND Node0_31_24 4.0814260000000044e-05A
R_0_31_24_1 Node0_31_24 Node0_31_25 76.99999999999991
R_0_31_24_3 Node0_31_24 Node1_31_24 3153.9199999999973
I_0_31_25 GND Node0_31_25 4.0814260000000044e-05A
R_0_31_25_1 Node0_31_25 Node0_31_26 76.99999999999991
R_0_31_25_3 Node0_31_25 Node1_31_25 3153.9199999999973
I_0_31_26 GND Node0_31_26 4.0814260000000044e-05A
R_0_31_26_1 Node0_31_26 Node0_31_27 76.99999999999991
R_0_31_26_3 Node0_31_26 Node1_31_26 3153.9199999999973
I_0_31_27 GND Node0_31_27 4.0814260000000044e-05A
R_0_31_27_1 Node0_31_27 Node0_31_28 76.99999999999991
R_0_31_27_3 Node0_31_27 Node1_31_27 3153.9199999999973
I_0_31_28 GND Node0_31_28 4.0814260000000044e-05A
R_0_31_28_1 Node0_31_28 Node0_31_29 77.00000000000006
R_0_31_28_3 Node0_31_28 Node1_31_28 3153.9199999999973
I_0_31_29 GND Node0_31_29 4.0814259999999895e-05A
R_0_31_29_1 Node0_31_29 Node0_31_30 77.00000000000006
R_0_31_29_3 Node0_31_29 Node1_31_29 3153.9200000000087
I_0_31_30 GND Node0_31_30 4.0814260000000044e-05A
R_0_31_30_1 Node0_31_30 Node0_31_31 76.99999999999991
R_0_31_30_3 Node0_31_30 Node1_31_30 3153.9199999999973
I_0_31_31 GND Node0_31_31 4.0814260000000044e-05A
R_0_31_31_3 Node0_31_31 Node1_31_31 3153.9199999999973
R_1_0_0_1 Node1_0_0 Node1_0_1 2.5000000000000004
Rsp_1_0_0_1 Node1_0_0 Node_sp_left 71.54069767441861
R_1_0_0_2 Node1_0_0 Node1_1_0 2.5000000000000004
Rsp_1_0_0_2 Node1_0_0 Node_sp_bot 71.54069767441861
R_1_0_0_3 Node1_0_0 Node2_0_0 10240.000000000002
R_1_0_1_1 Node1_0_1 Node1_0_2 2.5000000000000004
R_1_0_1_2 Node1_0_1 Node1_1_1 2.5000000000000004
Rsp_1_0_1_2 Node1_0_1 Node_sp_bot 71.54069767441861
R_1_0_1_3 Node1_0_1 Node2_0_1 10240.000000000002
R_1_0_2_1 Node1_0_2 Node1_0_3 2.5000000000000004
R_1_0_2_2 Node1_0_2 Node1_1_2 2.5000000000000004
Rsp_1_0_2_2 Node1_0_2 Node_sp_bot 71.54069767441861
R_1_0_2_3 Node1_0_2 Node2_0_2 10240.000000000002
R_1_0_3_1 Node1_0_3 Node1_0_4 2.5000000000000004
R_1_0_3_2 Node1_0_3 Node1_1_3 2.5000000000000004
Rsp_1_0_3_2 Node1_0_3 Node_sp_bot 71.54069767441861
R_1_0_3_3 Node1_0_3 Node2_0_3 10240.000000000002
R_1_0_4_1 Node1_0_4 Node1_0_5 2.5000000000000004
R_1_0_4_2 Node1_0_4 Node1_1_4 2.5000000000000004
Rsp_1_0_4_2 Node1_0_4 Node_sp_bot 71.54069767441861
R_1_0_4_3 Node1_0_4 Node2_0_4 10240.000000000002
R_1_0_5_1 Node1_0_5 Node1_0_6 2.5000000000000004
R_1_0_5_2 Node1_0_5 Node1_1_5 2.5000000000000004
Rsp_1_0_5_2 Node1_0_5 Node_sp_bot 71.54069767441861
R_1_0_5_3 Node1_0_5 Node2_0_5 10240.000000000002
R_1_0_6_1 Node1_0_6 Node1_0_7 2.5000000000000004
R_1_0_6_2 Node1_0_6 Node1_1_6 2.5000000000000004
Rsp_1_0_6_2 Node1_0_6 Node_sp_bot 71.54069767441861
R_1_0_6_3 Node1_0_6 Node2_0_6 10240.000000000002
R_1_0_7_1 Node1_0_7 Node1_0_8 2.5000000000000004
R_1_0_7_2 Node1_0_7 Node1_1_7 2.5000000000000004
Rsp_1_0_7_2 Node1_0_7 Node_sp_bot 71.54069767441861
R_1_0_7_3 Node1_0_7 Node2_0_7 10240.000000000002
R_1_0_8_1 Node1_0_8 Node1_0_9 2.5000000000000004
R_1_0_8_2 Node1_0_8 Node1_1_8 2.5000000000000004
Rsp_1_0_8_2 Node1_0_8 Node_sp_bot 71.54069767441861
R_1_0_8_3 Node1_0_8 Node2_0_8 10240.000000000002
R_1_0_9_1 Node1_0_9 Node1_0_10 2.5000000000000004
R_1_0_9_2 Node1_0_9 Node1_1_9 2.5000000000000004
Rsp_1_0_9_2 Node1_0_9 Node_sp_bot 71.54069767441861
R_1_0_9_3 Node1_0_9 Node2_0_9 10240.000000000002
R_1_0_10_1 Node1_0_10 Node1_0_11 2.5000000000000004
R_1_0_10_2 Node1_0_10 Node1_1_10 2.5000000000000004
Rsp_1_0_10_2 Node1_0_10 Node_sp_bot 71.54069767441861
R_1_0_10_3 Node1_0_10 Node2_0_10 10240.000000000002
R_1_0_11_1 Node1_0_11 Node1_0_12 2.5000000000000004
R_1_0_11_2 Node1_0_11 Node1_1_11 2.5000000000000004
Rsp_1_0_11_2 Node1_0_11 Node_sp_bot 71.54069767441861
R_1_0_11_3 Node1_0_11 Node2_0_11 10240.000000000002
R_1_0_12_1 Node1_0_12 Node1_0_13 2.5000000000000004
R_1_0_12_2 Node1_0_12 Node1_1_12 2.5000000000000004
Rsp_1_0_12_2 Node1_0_12 Node_sp_bot 71.54069767441861
R_1_0_12_3 Node1_0_12 Node2_0_12 10240.000000000002
R_1_0_13_1 Node1_0_13 Node1_0_14 2.5000000000000004
R_1_0_13_2 Node1_0_13 Node1_1_13 2.5000000000000004
Rsp_1_0_13_2 Node1_0_13 Node_sp_bot 71.54069767441861
R_1_0_13_3 Node1_0_13 Node2_0_13 10240.000000000002
R_1_0_14_1 Node1_0_14 Node1_0_15 2.5000000000000004
R_1_0_14_2 Node1_0_14 Node1_1_14 2.5000000000000004
Rsp_1_0_14_2 Node1_0_14 Node_sp_bot 71.54069767441861
R_1_0_14_3 Node1_0_14 Node2_0_14 10240.000000000002
R_1_0_15_1 Node1_0_15 Node1_0_16 2.5000000000000004
R_1_0_15_2 Node1_0_15 Node1_1_15 2.5000000000000004
Rsp_1_0_15_2 Node1_0_15 Node_sp_bot 71.54069767441861
R_1_0_15_3 Node1_0_15 Node2_0_15 10240.000000000002
R_1_0_16_1 Node1_0_16 Node1_0_17 2.5000000000000004
R_1_0_16_2 Node1_0_16 Node1_1_16 2.5000000000000004
Rsp_1_0_16_2 Node1_0_16 Node_sp_bot 71.54069767441861
R_1_0_16_3 Node1_0_16 Node2_0_16 10240.000000000002
R_1_0_17_1 Node1_0_17 Node1_0_18 2.5000000000000004
R_1_0_17_2 Node1_0_17 Node1_1_17 2.5000000000000004
Rsp_1_0_17_2 Node1_0_17 Node_sp_bot 71.54069767441861
R_1_0_17_3 Node1_0_17 Node2_0_17 10240.000000000002
R_1_0_18_1 Node1_0_18 Node1_0_19 2.5000000000000004
R_1_0_18_2 Node1_0_18 Node1_1_18 2.5000000000000004
Rsp_1_0_18_2 Node1_0_18 Node_sp_bot 71.54069767441861
R_1_0_18_3 Node1_0_18 Node2_0_18 10240.000000000002
R_1_0_19_1 Node1_0_19 Node1_0_20 2.5000000000000004
R_1_0_19_2 Node1_0_19 Node1_1_19 2.5000000000000004
Rsp_1_0_19_2 Node1_0_19 Node_sp_bot 71.54069767441861
R_1_0_19_3 Node1_0_19 Node2_0_19 10240.000000000002
R_1_0_20_1 Node1_0_20 Node1_0_21 2.5000000000000004
R_1_0_20_2 Node1_0_20 Node1_1_20 2.5000000000000004
Rsp_1_0_20_2 Node1_0_20 Node_sp_bot 71.54069767441861
R_1_0_20_3 Node1_0_20 Node2_0_20 10240.000000000002
R_1_0_21_1 Node1_0_21 Node1_0_22 2.5000000000000004
R_1_0_21_2 Node1_0_21 Node1_1_21 2.5000000000000004
Rsp_1_0_21_2 Node1_0_21 Node_sp_bot 71.54069767441861
R_1_0_21_3 Node1_0_21 Node2_0_21 10240.000000000002
R_1_0_22_1 Node1_0_22 Node1_0_23 2.5000000000000004
R_1_0_22_2 Node1_0_22 Node1_1_22 2.5000000000000004
Rsp_1_0_22_2 Node1_0_22 Node_sp_bot 71.54069767441861
R_1_0_22_3 Node1_0_22 Node2_0_22 10240.000000000002
R_1_0_23_1 Node1_0_23 Node1_0_24 2.5000000000000004
R_1_0_23_2 Node1_0_23 Node1_1_23 2.5000000000000004
Rsp_1_0_23_2 Node1_0_23 Node_sp_bot 71.54069767441861
R_1_0_23_3 Node1_0_23 Node2_0_23 10240.000000000002
R_1_0_24_1 Node1_0_24 Node1_0_25 2.5000000000000004
R_1_0_24_2 Node1_0_24 Node1_1_24 2.5000000000000004
Rsp_1_0_24_2 Node1_0_24 Node_sp_bot 71.54069767441861
R_1_0_24_3 Node1_0_24 Node2_0_24 10240.000000000002
R_1_0_25_1 Node1_0_25 Node1_0_26 2.5000000000000004
R_1_0_25_2 Node1_0_25 Node1_1_25 2.5000000000000004
Rsp_1_0_25_2 Node1_0_25 Node_sp_bot 71.54069767441861
R_1_0_25_3 Node1_0_25 Node2_0_25 10240.000000000002
R_1_0_26_1 Node1_0_26 Node1_0_27 2.5000000000000004
R_1_0_26_2 Node1_0_26 Node1_1_26 2.5000000000000004
Rsp_1_0_26_2 Node1_0_26 Node_sp_bot 71.54069767441861
R_1_0_26_3 Node1_0_26 Node2_0_26 10240.000000000002
R_1_0_27_1 Node1_0_27 Node1_0_28 2.5000000000000004
R_1_0_27_2 Node1_0_27 Node1_1_27 2.5000000000000004
Rsp_1_0_27_2 Node1_0_27 Node_sp_bot 71.54069767441861
R_1_0_27_3 Node1_0_27 Node2_0_27 10240.000000000002
R_1_0_28_1 Node1_0_28 Node1_0_29 2.5000000000000004
R_1_0_28_2 Node1_0_28 Node1_1_28 2.5000000000000004
Rsp_1_0_28_2 Node1_0_28 Node_sp_bot 71.54069767441861
R_1_0_28_3 Node1_0_28 Node2_0_28 10240.000000000002
R_1_0_29_1 Node1_0_29 Node1_0_30 2.5000000000000004
R_1_0_29_2 Node1_0_29 Node1_1_29 2.5000000000000004
Rsp_1_0_29_2 Node1_0_29 Node_sp_bot 71.54069767441861
R_1_0_29_3 Node1_0_29 Node2_0_29 10240.000000000002
R_1_0_30_1 Node1_0_30 Node1_0_31 2.5000000000000004
R_1_0_30_2 Node1_0_30 Node1_1_30 2.5000000000000004
Rsp_1_0_30_2 Node1_0_30 Node_sp_bot 71.54069767441861
R_1_0_30_3 Node1_0_30 Node2_0_30 10240.000000000002
Rsp_1_0_31_1 Node1_0_31 Node_sp_right 71.54069767441861
R_1_0_31_2 Node1_0_31 Node1_1_31 2.5000000000000004
Rsp_1_0_31_2 Node1_0_31 Node_sp_bot 71.54069767441861
R_1_0_31_3 Node1_0_31 Node2_0_31 10240.000000000002
R_1_1_0_1 Node1_1_0 Node1_1_1 2.5000000000000004
Rsp_1_1_0_1 Node1_1_0 Node_sp_left 71.54069767441861
R_1_1_0_2 Node1_1_0 Node1_2_0 2.5000000000000004
R_1_1_0_3 Node1_1_0 Node2_1_0 10240.000000000002
R_1_1_1_1 Node1_1_1 Node1_1_2 2.5000000000000004
R_1_1_1_2 Node1_1_1 Node1_2_1 2.5000000000000004
R_1_1_1_3 Node1_1_1 Node2_1_1 10240.000000000002
R_1_1_2_1 Node1_1_2 Node1_1_3 2.5000000000000004
R_1_1_2_2 Node1_1_2 Node1_2_2 2.5000000000000004
R_1_1_2_3 Node1_1_2 Node2_1_2 10240.000000000002
R_1_1_3_1 Node1_1_3 Node1_1_4 2.5000000000000004
R_1_1_3_2 Node1_1_3 Node1_2_3 2.5000000000000004
R_1_1_3_3 Node1_1_3 Node2_1_3 10240.000000000002
R_1_1_4_1 Node1_1_4 Node1_1_5 2.5000000000000004
R_1_1_4_2 Node1_1_4 Node1_2_4 2.5000000000000004
R_1_1_4_3 Node1_1_4 Node2_1_4 10240.000000000002
R_1_1_5_1 Node1_1_5 Node1_1_6 2.5000000000000004
R_1_1_5_2 Node1_1_5 Node1_2_5 2.5000000000000004
R_1_1_5_3 Node1_1_5 Node2_1_5 10240.000000000002
R_1_1_6_1 Node1_1_6 Node1_1_7 2.5000000000000004
R_1_1_6_2 Node1_1_6 Node1_2_6 2.5000000000000004
R_1_1_6_3 Node1_1_6 Node2_1_6 10240.000000000002
R_1_1_7_1 Node1_1_7 Node1_1_8 2.5000000000000004
R_1_1_7_2 Node1_1_7 Node1_2_7 2.5000000000000004
R_1_1_7_3 Node1_1_7 Node2_1_7 10240.000000000002
R_1_1_8_1 Node1_1_8 Node1_1_9 2.5000000000000004
R_1_1_8_2 Node1_1_8 Node1_2_8 2.5000000000000004
R_1_1_8_3 Node1_1_8 Node2_1_8 10240.000000000002
R_1_1_9_1 Node1_1_9 Node1_1_10 2.5000000000000004
R_1_1_9_2 Node1_1_9 Node1_2_9 2.5000000000000004
R_1_1_9_3 Node1_1_9 Node2_1_9 10240.000000000002
R_1_1_10_1 Node1_1_10 Node1_1_11 2.5000000000000004
R_1_1_10_2 Node1_1_10 Node1_2_10 2.5000000000000004
R_1_1_10_3 Node1_1_10 Node2_1_10 10240.000000000002
R_1_1_11_1 Node1_1_11 Node1_1_12 2.5000000000000004
R_1_1_11_2 Node1_1_11 Node1_2_11 2.5000000000000004
R_1_1_11_3 Node1_1_11 Node2_1_11 10240.000000000002
R_1_1_12_1 Node1_1_12 Node1_1_13 2.5000000000000004
R_1_1_12_2 Node1_1_12 Node1_2_12 2.5000000000000004
R_1_1_12_3 Node1_1_12 Node2_1_12 10240.000000000002
R_1_1_13_1 Node1_1_13 Node1_1_14 2.5000000000000004
R_1_1_13_2 Node1_1_13 Node1_2_13 2.5000000000000004
R_1_1_13_3 Node1_1_13 Node2_1_13 10240.000000000002
R_1_1_14_1 Node1_1_14 Node1_1_15 2.5000000000000004
R_1_1_14_2 Node1_1_14 Node1_2_14 2.5000000000000004
R_1_1_14_3 Node1_1_14 Node2_1_14 10240.000000000002
R_1_1_15_1 Node1_1_15 Node1_1_16 2.5000000000000004
R_1_1_15_2 Node1_1_15 Node1_2_15 2.5000000000000004
R_1_1_15_3 Node1_1_15 Node2_1_15 10240.000000000002
R_1_1_16_1 Node1_1_16 Node1_1_17 2.5000000000000004
R_1_1_16_2 Node1_1_16 Node1_2_16 2.5000000000000004
R_1_1_16_3 Node1_1_16 Node2_1_16 10240.000000000002
R_1_1_17_1 Node1_1_17 Node1_1_18 2.5000000000000004
R_1_1_17_2 Node1_1_17 Node1_2_17 2.5000000000000004
R_1_1_17_3 Node1_1_17 Node2_1_17 10240.000000000002
R_1_1_18_1 Node1_1_18 Node1_1_19 2.5000000000000004
R_1_1_18_2 Node1_1_18 Node1_2_18 2.5000000000000004
R_1_1_18_3 Node1_1_18 Node2_1_18 10240.000000000002
R_1_1_19_1 Node1_1_19 Node1_1_20 2.5000000000000004
R_1_1_19_2 Node1_1_19 Node1_2_19 2.5000000000000004
R_1_1_19_3 Node1_1_19 Node2_1_19 10240.000000000002
R_1_1_20_1 Node1_1_20 Node1_1_21 2.5000000000000004
R_1_1_20_2 Node1_1_20 Node1_2_20 2.5000000000000004
R_1_1_20_3 Node1_1_20 Node2_1_20 10240.000000000002
R_1_1_21_1 Node1_1_21 Node1_1_22 2.5000000000000004
R_1_1_21_2 Node1_1_21 Node1_2_21 2.5000000000000004
R_1_1_21_3 Node1_1_21 Node2_1_21 10240.000000000002
R_1_1_22_1 Node1_1_22 Node1_1_23 2.5000000000000004
R_1_1_22_2 Node1_1_22 Node1_2_22 2.5000000000000004
R_1_1_22_3 Node1_1_22 Node2_1_22 10240.000000000002
R_1_1_23_1 Node1_1_23 Node1_1_24 2.5000000000000004
R_1_1_23_2 Node1_1_23 Node1_2_23 2.5000000000000004
R_1_1_23_3 Node1_1_23 Node2_1_23 10240.000000000002
R_1_1_24_1 Node1_1_24 Node1_1_25 2.5000000000000004
R_1_1_24_2 Node1_1_24 Node1_2_24 2.5000000000000004
R_1_1_24_3 Node1_1_24 Node2_1_24 10240.000000000002
R_1_1_25_1 Node1_1_25 Node1_1_26 2.5000000000000004
R_1_1_25_2 Node1_1_25 Node1_2_25 2.5000000000000004
R_1_1_25_3 Node1_1_25 Node2_1_25 10240.000000000002
R_1_1_26_1 Node1_1_26 Node1_1_27 2.5000000000000004
R_1_1_26_2 Node1_1_26 Node1_2_26 2.5000000000000004
R_1_1_26_3 Node1_1_26 Node2_1_26 10240.000000000002
R_1_1_27_1 Node1_1_27 Node1_1_28 2.5000000000000004
R_1_1_27_2 Node1_1_27 Node1_2_27 2.5000000000000004
R_1_1_27_3 Node1_1_27 Node2_1_27 10240.000000000002
R_1_1_28_1 Node1_1_28 Node1_1_29 2.5000000000000004
R_1_1_28_2 Node1_1_28 Node1_2_28 2.5000000000000004
R_1_1_28_3 Node1_1_28 Node2_1_28 10240.000000000002
R_1_1_29_1 Node1_1_29 Node1_1_30 2.5000000000000004
R_1_1_29_2 Node1_1_29 Node1_2_29 2.5000000000000004
R_1_1_29_3 Node1_1_29 Node2_1_29 10240.000000000002
R_1_1_30_1 Node1_1_30 Node1_1_31 2.5000000000000004
R_1_1_30_2 Node1_1_30 Node1_2_30 2.5000000000000004
R_1_1_30_3 Node1_1_30 Node2_1_30 10240.000000000002
Rsp_1_1_31_1 Node1_1_31 Node_sp_right 71.54069767441861
R_1_1_31_2 Node1_1_31 Node1_2_31 2.5000000000000004
R_1_1_31_3 Node1_1_31 Node2_1_31 10240.000000000002
R_1_2_0_1 Node1_2_0 Node1_2_1 2.5000000000000004
Rsp_1_2_0_1 Node1_2_0 Node_sp_left 71.54069767441861
R_1_2_0_2 Node1_2_0 Node1_3_0 2.5000000000000004
R_1_2_0_3 Node1_2_0 Node2_2_0 10240.000000000002
R_1_2_1_1 Node1_2_1 Node1_2_2 2.5000000000000004
R_1_2_1_2 Node1_2_1 Node1_3_1 2.5000000000000004
R_1_2_1_3 Node1_2_1 Node2_2_1 10240.000000000002
R_1_2_2_1 Node1_2_2 Node1_2_3 2.5000000000000004
R_1_2_2_2 Node1_2_2 Node1_3_2 2.5000000000000004
R_1_2_2_3 Node1_2_2 Node2_2_2 10240.000000000002
R_1_2_3_1 Node1_2_3 Node1_2_4 2.5000000000000004
R_1_2_3_2 Node1_2_3 Node1_3_3 2.5000000000000004
R_1_2_3_3 Node1_2_3 Node2_2_3 10240.000000000002
R_1_2_4_1 Node1_2_4 Node1_2_5 2.5000000000000004
R_1_2_4_2 Node1_2_4 Node1_3_4 2.5000000000000004
R_1_2_4_3 Node1_2_4 Node2_2_4 10240.000000000002
R_1_2_5_1 Node1_2_5 Node1_2_6 2.5000000000000004
R_1_2_5_2 Node1_2_5 Node1_3_5 2.5000000000000004
R_1_2_5_3 Node1_2_5 Node2_2_5 10240.000000000002
R_1_2_6_1 Node1_2_6 Node1_2_7 2.5000000000000004
R_1_2_6_2 Node1_2_6 Node1_3_6 2.5000000000000004
R_1_2_6_3 Node1_2_6 Node2_2_6 10240.000000000002
R_1_2_7_1 Node1_2_7 Node1_2_8 2.5000000000000004
R_1_2_7_2 Node1_2_7 Node1_3_7 2.5000000000000004
R_1_2_7_3 Node1_2_7 Node2_2_7 10240.000000000002
R_1_2_8_1 Node1_2_8 Node1_2_9 2.5000000000000004
R_1_2_8_2 Node1_2_8 Node1_3_8 2.5000000000000004
R_1_2_8_3 Node1_2_8 Node2_2_8 10240.000000000002
R_1_2_9_1 Node1_2_9 Node1_2_10 2.5000000000000004
R_1_2_9_2 Node1_2_9 Node1_3_9 2.5000000000000004
R_1_2_9_3 Node1_2_9 Node2_2_9 10240.000000000002
R_1_2_10_1 Node1_2_10 Node1_2_11 2.5000000000000004
R_1_2_10_2 Node1_2_10 Node1_3_10 2.5000000000000004
R_1_2_10_3 Node1_2_10 Node2_2_10 10240.000000000002
R_1_2_11_1 Node1_2_11 Node1_2_12 2.5000000000000004
R_1_2_11_2 Node1_2_11 Node1_3_11 2.5000000000000004
R_1_2_11_3 Node1_2_11 Node2_2_11 10240.000000000002
R_1_2_12_1 Node1_2_12 Node1_2_13 2.5000000000000004
R_1_2_12_2 Node1_2_12 Node1_3_12 2.5000000000000004
R_1_2_12_3 Node1_2_12 Node2_2_12 10240.000000000002
R_1_2_13_1 Node1_2_13 Node1_2_14 2.5000000000000004
R_1_2_13_2 Node1_2_13 Node1_3_13 2.5000000000000004
R_1_2_13_3 Node1_2_13 Node2_2_13 10240.000000000002
R_1_2_14_1 Node1_2_14 Node1_2_15 2.5000000000000004
R_1_2_14_2 Node1_2_14 Node1_3_14 2.5000000000000004
R_1_2_14_3 Node1_2_14 Node2_2_14 10240.000000000002
R_1_2_15_1 Node1_2_15 Node1_2_16 2.5000000000000004
R_1_2_15_2 Node1_2_15 Node1_3_15 2.5000000000000004
R_1_2_15_3 Node1_2_15 Node2_2_15 10240.000000000002
R_1_2_16_1 Node1_2_16 Node1_2_17 2.5000000000000004
R_1_2_16_2 Node1_2_16 Node1_3_16 2.5000000000000004
R_1_2_16_3 Node1_2_16 Node2_2_16 10240.000000000002
R_1_2_17_1 Node1_2_17 Node1_2_18 2.5000000000000004
R_1_2_17_2 Node1_2_17 Node1_3_17 2.5000000000000004
R_1_2_17_3 Node1_2_17 Node2_2_17 10240.000000000002
R_1_2_18_1 Node1_2_18 Node1_2_19 2.5000000000000004
R_1_2_18_2 Node1_2_18 Node1_3_18 2.5000000000000004
R_1_2_18_3 Node1_2_18 Node2_2_18 10240.000000000002
R_1_2_19_1 Node1_2_19 Node1_2_20 2.5000000000000004
R_1_2_19_2 Node1_2_19 Node1_3_19 2.5000000000000004
R_1_2_19_3 Node1_2_19 Node2_2_19 10240.000000000002
R_1_2_20_1 Node1_2_20 Node1_2_21 2.5000000000000004
R_1_2_20_2 Node1_2_20 Node1_3_20 2.5000000000000004
R_1_2_20_3 Node1_2_20 Node2_2_20 10240.000000000002
R_1_2_21_1 Node1_2_21 Node1_2_22 2.5000000000000004
R_1_2_21_2 Node1_2_21 Node1_3_21 2.5000000000000004
R_1_2_21_3 Node1_2_21 Node2_2_21 10240.000000000002
R_1_2_22_1 Node1_2_22 Node1_2_23 2.5000000000000004
R_1_2_22_2 Node1_2_22 Node1_3_22 2.5000000000000004
R_1_2_22_3 Node1_2_22 Node2_2_22 10240.000000000002
R_1_2_23_1 Node1_2_23 Node1_2_24 2.5000000000000004
R_1_2_23_2 Node1_2_23 Node1_3_23 2.5000000000000004
R_1_2_23_3 Node1_2_23 Node2_2_23 10240.000000000002
R_1_2_24_1 Node1_2_24 Node1_2_25 2.5000000000000004
R_1_2_24_2 Node1_2_24 Node1_3_24 2.5000000000000004
R_1_2_24_3 Node1_2_24 Node2_2_24 10240.000000000002
R_1_2_25_1 Node1_2_25 Node1_2_26 2.5000000000000004
R_1_2_25_2 Node1_2_25 Node1_3_25 2.5000000000000004
R_1_2_25_3 Node1_2_25 Node2_2_25 10240.000000000002
R_1_2_26_1 Node1_2_26 Node1_2_27 2.5000000000000004
R_1_2_26_2 Node1_2_26 Node1_3_26 2.5000000000000004
R_1_2_26_3 Node1_2_26 Node2_2_26 10240.000000000002
R_1_2_27_1 Node1_2_27 Node1_2_28 2.5000000000000004
R_1_2_27_2 Node1_2_27 Node1_3_27 2.5000000000000004
R_1_2_27_3 Node1_2_27 Node2_2_27 10240.000000000002
R_1_2_28_1 Node1_2_28 Node1_2_29 2.5000000000000004
R_1_2_28_2 Node1_2_28 Node1_3_28 2.5000000000000004
R_1_2_28_3 Node1_2_28 Node2_2_28 10240.000000000002
R_1_2_29_1 Node1_2_29 Node1_2_30 2.5000000000000004
R_1_2_29_2 Node1_2_29 Node1_3_29 2.5000000000000004
R_1_2_29_3 Node1_2_29 Node2_2_29 10240.000000000002
R_1_2_30_1 Node1_2_30 Node1_2_31 2.5000000000000004
R_1_2_30_2 Node1_2_30 Node1_3_30 2.5000000000000004
R_1_2_30_3 Node1_2_30 Node2_2_30 10240.000000000002
Rsp_1_2_31_1 Node1_2_31 Node_sp_right 71.54069767441861
R_1_2_31_2 Node1_2_31 Node1_3_31 2.5000000000000004
R_1_2_31_3 Node1_2_31 Node2_2_31 10240.000000000002
R_1_3_0_1 Node1_3_0 Node1_3_1 2.5000000000000004
Rsp_1_3_0_1 Node1_3_0 Node_sp_left 71.54069767441861
R_1_3_0_2 Node1_3_0 Node1_4_0 2.5000000000000004
R_1_3_0_3 Node1_3_0 Node2_3_0 10240.000000000002
R_1_3_1_1 Node1_3_1 Node1_3_2 2.5000000000000004
R_1_3_1_2 Node1_3_1 Node1_4_1 2.5000000000000004
R_1_3_1_3 Node1_3_1 Node2_3_1 10240.000000000002
R_1_3_2_1 Node1_3_2 Node1_3_3 2.5000000000000004
R_1_3_2_2 Node1_3_2 Node1_4_2 2.5000000000000004
R_1_3_2_3 Node1_3_2 Node2_3_2 10240.000000000002
R_1_3_3_1 Node1_3_3 Node1_3_4 2.5000000000000004
R_1_3_3_2 Node1_3_3 Node1_4_3 2.5000000000000004
R_1_3_3_3 Node1_3_3 Node2_3_3 10240.000000000002
R_1_3_4_1 Node1_3_4 Node1_3_5 2.5000000000000004
R_1_3_4_2 Node1_3_4 Node1_4_4 2.5000000000000004
R_1_3_4_3 Node1_3_4 Node2_3_4 10240.000000000002
R_1_3_5_1 Node1_3_5 Node1_3_6 2.5000000000000004
R_1_3_5_2 Node1_3_5 Node1_4_5 2.5000000000000004
R_1_3_5_3 Node1_3_5 Node2_3_5 10240.000000000002
R_1_3_6_1 Node1_3_6 Node1_3_7 2.5000000000000004
R_1_3_6_2 Node1_3_6 Node1_4_6 2.5000000000000004
R_1_3_6_3 Node1_3_6 Node2_3_6 10240.000000000002
R_1_3_7_1 Node1_3_7 Node1_3_8 2.5000000000000004
R_1_3_7_2 Node1_3_7 Node1_4_7 2.5000000000000004
R_1_3_7_3 Node1_3_7 Node2_3_7 10240.000000000002
R_1_3_8_1 Node1_3_8 Node1_3_9 2.5000000000000004
R_1_3_8_2 Node1_3_8 Node1_4_8 2.5000000000000004
R_1_3_8_3 Node1_3_8 Node2_3_8 10240.000000000002
R_1_3_9_1 Node1_3_9 Node1_3_10 2.5000000000000004
R_1_3_9_2 Node1_3_9 Node1_4_9 2.5000000000000004
R_1_3_9_3 Node1_3_9 Node2_3_9 10240.000000000002
R_1_3_10_1 Node1_3_10 Node1_3_11 2.5000000000000004
R_1_3_10_2 Node1_3_10 Node1_4_10 2.5000000000000004
R_1_3_10_3 Node1_3_10 Node2_3_10 10240.000000000002
R_1_3_11_1 Node1_3_11 Node1_3_12 2.5000000000000004
R_1_3_11_2 Node1_3_11 Node1_4_11 2.5000000000000004
R_1_3_11_3 Node1_3_11 Node2_3_11 10240.000000000002
R_1_3_12_1 Node1_3_12 Node1_3_13 2.5000000000000004
R_1_3_12_2 Node1_3_12 Node1_4_12 2.5000000000000004
R_1_3_12_3 Node1_3_12 Node2_3_12 10240.000000000002
R_1_3_13_1 Node1_3_13 Node1_3_14 2.5000000000000004
R_1_3_13_2 Node1_3_13 Node1_4_13 2.5000000000000004
R_1_3_13_3 Node1_3_13 Node2_3_13 10240.000000000002
R_1_3_14_1 Node1_3_14 Node1_3_15 2.5000000000000004
R_1_3_14_2 Node1_3_14 Node1_4_14 2.5000000000000004
R_1_3_14_3 Node1_3_14 Node2_3_14 10240.000000000002
R_1_3_15_1 Node1_3_15 Node1_3_16 2.5000000000000004
R_1_3_15_2 Node1_3_15 Node1_4_15 2.5000000000000004
R_1_3_15_3 Node1_3_15 Node2_3_15 10240.000000000002
R_1_3_16_1 Node1_3_16 Node1_3_17 2.5000000000000004
R_1_3_16_2 Node1_3_16 Node1_4_16 2.5000000000000004
R_1_3_16_3 Node1_3_16 Node2_3_16 10240.000000000002
R_1_3_17_1 Node1_3_17 Node1_3_18 2.5000000000000004
R_1_3_17_2 Node1_3_17 Node1_4_17 2.5000000000000004
R_1_3_17_3 Node1_3_17 Node2_3_17 10240.000000000002
R_1_3_18_1 Node1_3_18 Node1_3_19 2.5000000000000004
R_1_3_18_2 Node1_3_18 Node1_4_18 2.5000000000000004
R_1_3_18_3 Node1_3_18 Node2_3_18 10240.000000000002
R_1_3_19_1 Node1_3_19 Node1_3_20 2.5000000000000004
R_1_3_19_2 Node1_3_19 Node1_4_19 2.5000000000000004
R_1_3_19_3 Node1_3_19 Node2_3_19 10240.000000000002
R_1_3_20_1 Node1_3_20 Node1_3_21 2.5000000000000004
R_1_3_20_2 Node1_3_20 Node1_4_20 2.5000000000000004
R_1_3_20_3 Node1_3_20 Node2_3_20 10240.000000000002
R_1_3_21_1 Node1_3_21 Node1_3_22 2.5000000000000004
R_1_3_21_2 Node1_3_21 Node1_4_21 2.5000000000000004
R_1_3_21_3 Node1_3_21 Node2_3_21 10240.000000000002
R_1_3_22_1 Node1_3_22 Node1_3_23 2.5000000000000004
R_1_3_22_2 Node1_3_22 Node1_4_22 2.5000000000000004
R_1_3_22_3 Node1_3_22 Node2_3_22 10240.000000000002
R_1_3_23_1 Node1_3_23 Node1_3_24 2.5000000000000004
R_1_3_23_2 Node1_3_23 Node1_4_23 2.5000000000000004
R_1_3_23_3 Node1_3_23 Node2_3_23 10240.000000000002
R_1_3_24_1 Node1_3_24 Node1_3_25 2.5000000000000004
R_1_3_24_2 Node1_3_24 Node1_4_24 2.5000000000000004
R_1_3_24_3 Node1_3_24 Node2_3_24 10240.000000000002
R_1_3_25_1 Node1_3_25 Node1_3_26 2.5000000000000004
R_1_3_25_2 Node1_3_25 Node1_4_25 2.5000000000000004
R_1_3_25_3 Node1_3_25 Node2_3_25 10240.000000000002
R_1_3_26_1 Node1_3_26 Node1_3_27 2.5000000000000004
R_1_3_26_2 Node1_3_26 Node1_4_26 2.5000000000000004
R_1_3_26_3 Node1_3_26 Node2_3_26 10240.000000000002
R_1_3_27_1 Node1_3_27 Node1_3_28 2.5000000000000004
R_1_3_27_2 Node1_3_27 Node1_4_27 2.5000000000000004
R_1_3_27_3 Node1_3_27 Node2_3_27 10240.000000000002
R_1_3_28_1 Node1_3_28 Node1_3_29 2.5000000000000004
R_1_3_28_2 Node1_3_28 Node1_4_28 2.5000000000000004
R_1_3_28_3 Node1_3_28 Node2_3_28 10240.000000000002
R_1_3_29_1 Node1_3_29 Node1_3_30 2.5000000000000004
R_1_3_29_2 Node1_3_29 Node1_4_29 2.5000000000000004
R_1_3_29_3 Node1_3_29 Node2_3_29 10240.000000000002
R_1_3_30_1 Node1_3_30 Node1_3_31 2.5000000000000004
R_1_3_30_2 Node1_3_30 Node1_4_30 2.5000000000000004
R_1_3_30_3 Node1_3_30 Node2_3_30 10240.000000000002
Rsp_1_3_31_1 Node1_3_31 Node_sp_right 71.54069767441861
R_1_3_31_2 Node1_3_31 Node1_4_31 2.5000000000000004
R_1_3_31_3 Node1_3_31 Node2_3_31 10240.000000000002
R_1_4_0_1 Node1_4_0 Node1_4_1 2.5000000000000004
Rsp_1_4_0_1 Node1_4_0 Node_sp_left 71.54069767441861
R_1_4_0_2 Node1_4_0 Node1_5_0 2.5000000000000004
R_1_4_0_3 Node1_4_0 Node2_4_0 10240.000000000002
R_1_4_1_1 Node1_4_1 Node1_4_2 2.5000000000000004
R_1_4_1_2 Node1_4_1 Node1_5_1 2.5000000000000004
R_1_4_1_3 Node1_4_1 Node2_4_1 10240.000000000002
R_1_4_2_1 Node1_4_2 Node1_4_3 2.5000000000000004
R_1_4_2_2 Node1_4_2 Node1_5_2 2.5000000000000004
R_1_4_2_3 Node1_4_2 Node2_4_2 10240.000000000002
R_1_4_3_1 Node1_4_3 Node1_4_4 2.5000000000000004
R_1_4_3_2 Node1_4_3 Node1_5_3 2.5000000000000004
R_1_4_3_3 Node1_4_3 Node2_4_3 10240.000000000002
R_1_4_4_1 Node1_4_4 Node1_4_5 2.5000000000000004
R_1_4_4_2 Node1_4_4 Node1_5_4 2.5000000000000004
R_1_4_4_3 Node1_4_4 Node2_4_4 10240.000000000002
R_1_4_5_1 Node1_4_5 Node1_4_6 2.5000000000000004
R_1_4_5_2 Node1_4_5 Node1_5_5 2.5000000000000004
R_1_4_5_3 Node1_4_5 Node2_4_5 10240.000000000002
R_1_4_6_1 Node1_4_6 Node1_4_7 2.5000000000000004
R_1_4_6_2 Node1_4_6 Node1_5_6 2.5000000000000004
R_1_4_6_3 Node1_4_6 Node2_4_6 10240.000000000002
R_1_4_7_1 Node1_4_7 Node1_4_8 2.5000000000000004
R_1_4_7_2 Node1_4_7 Node1_5_7 2.5000000000000004
R_1_4_7_3 Node1_4_7 Node2_4_7 10240.000000000002
R_1_4_8_1 Node1_4_8 Node1_4_9 2.5000000000000004
R_1_4_8_2 Node1_4_8 Node1_5_8 2.5000000000000004
R_1_4_8_3 Node1_4_8 Node2_4_8 10240.000000000002
R_1_4_9_1 Node1_4_9 Node1_4_10 2.5000000000000004
R_1_4_9_2 Node1_4_9 Node1_5_9 2.5000000000000004
R_1_4_9_3 Node1_4_9 Node2_4_9 10240.000000000002
R_1_4_10_1 Node1_4_10 Node1_4_11 2.5000000000000004
R_1_4_10_2 Node1_4_10 Node1_5_10 2.5000000000000004
R_1_4_10_3 Node1_4_10 Node2_4_10 10240.000000000002
R_1_4_11_1 Node1_4_11 Node1_4_12 2.5000000000000004
R_1_4_11_2 Node1_4_11 Node1_5_11 2.5000000000000004
R_1_4_11_3 Node1_4_11 Node2_4_11 10240.000000000002
R_1_4_12_1 Node1_4_12 Node1_4_13 2.5000000000000004
R_1_4_12_2 Node1_4_12 Node1_5_12 2.5000000000000004
R_1_4_12_3 Node1_4_12 Node2_4_12 10240.000000000002
R_1_4_13_1 Node1_4_13 Node1_4_14 2.5000000000000004
R_1_4_13_2 Node1_4_13 Node1_5_13 2.5000000000000004
R_1_4_13_3 Node1_4_13 Node2_4_13 10240.000000000002
R_1_4_14_1 Node1_4_14 Node1_4_15 2.5000000000000004
R_1_4_14_2 Node1_4_14 Node1_5_14 2.5000000000000004
R_1_4_14_3 Node1_4_14 Node2_4_14 10240.000000000002
R_1_4_15_1 Node1_4_15 Node1_4_16 2.5000000000000004
R_1_4_15_2 Node1_4_15 Node1_5_15 2.5000000000000004
R_1_4_15_3 Node1_4_15 Node2_4_15 10240.000000000002
R_1_4_16_1 Node1_4_16 Node1_4_17 2.5000000000000004
R_1_4_16_2 Node1_4_16 Node1_5_16 2.5000000000000004
R_1_4_16_3 Node1_4_16 Node2_4_16 10240.000000000002
R_1_4_17_1 Node1_4_17 Node1_4_18 2.5000000000000004
R_1_4_17_2 Node1_4_17 Node1_5_17 2.5000000000000004
R_1_4_17_3 Node1_4_17 Node2_4_17 10240.000000000002
R_1_4_18_1 Node1_4_18 Node1_4_19 2.5000000000000004
R_1_4_18_2 Node1_4_18 Node1_5_18 2.5000000000000004
R_1_4_18_3 Node1_4_18 Node2_4_18 10240.000000000002
R_1_4_19_1 Node1_4_19 Node1_4_20 2.5000000000000004
R_1_4_19_2 Node1_4_19 Node1_5_19 2.5000000000000004
R_1_4_19_3 Node1_4_19 Node2_4_19 10240.000000000002
R_1_4_20_1 Node1_4_20 Node1_4_21 2.5000000000000004
R_1_4_20_2 Node1_4_20 Node1_5_20 2.5000000000000004
R_1_4_20_3 Node1_4_20 Node2_4_20 10240.000000000002
R_1_4_21_1 Node1_4_21 Node1_4_22 2.5000000000000004
R_1_4_21_2 Node1_4_21 Node1_5_21 2.5000000000000004
R_1_4_21_3 Node1_4_21 Node2_4_21 10240.000000000002
R_1_4_22_1 Node1_4_22 Node1_4_23 2.5000000000000004
R_1_4_22_2 Node1_4_22 Node1_5_22 2.5000000000000004
R_1_4_22_3 Node1_4_22 Node2_4_22 10240.000000000002
R_1_4_23_1 Node1_4_23 Node1_4_24 2.5000000000000004
R_1_4_23_2 Node1_4_23 Node1_5_23 2.5000000000000004
R_1_4_23_3 Node1_4_23 Node2_4_23 10240.000000000002
R_1_4_24_1 Node1_4_24 Node1_4_25 2.5000000000000004
R_1_4_24_2 Node1_4_24 Node1_5_24 2.5000000000000004
R_1_4_24_3 Node1_4_24 Node2_4_24 10240.000000000002
R_1_4_25_1 Node1_4_25 Node1_4_26 2.5000000000000004
R_1_4_25_2 Node1_4_25 Node1_5_25 2.5000000000000004
R_1_4_25_3 Node1_4_25 Node2_4_25 10240.000000000002
R_1_4_26_1 Node1_4_26 Node1_4_27 2.5000000000000004
R_1_4_26_2 Node1_4_26 Node1_5_26 2.5000000000000004
R_1_4_26_3 Node1_4_26 Node2_4_26 10240.000000000002
R_1_4_27_1 Node1_4_27 Node1_4_28 2.5000000000000004
R_1_4_27_2 Node1_4_27 Node1_5_27 2.5000000000000004
R_1_4_27_3 Node1_4_27 Node2_4_27 10240.000000000002
R_1_4_28_1 Node1_4_28 Node1_4_29 2.5000000000000004
R_1_4_28_2 Node1_4_28 Node1_5_28 2.5000000000000004
R_1_4_28_3 Node1_4_28 Node2_4_28 10240.000000000002
R_1_4_29_1 Node1_4_29 Node1_4_30 2.5000000000000004
R_1_4_29_2 Node1_4_29 Node1_5_29 2.5000000000000004
R_1_4_29_3 Node1_4_29 Node2_4_29 10240.000000000002
R_1_4_30_1 Node1_4_30 Node1_4_31 2.5000000000000004
R_1_4_30_2 Node1_4_30 Node1_5_30 2.5000000000000004
R_1_4_30_3 Node1_4_30 Node2_4_30 10240.000000000002
Rsp_1_4_31_1 Node1_4_31 Node_sp_right 71.54069767441861
R_1_4_31_2 Node1_4_31 Node1_5_31 2.5000000000000004
R_1_4_31_3 Node1_4_31 Node2_4_31 10240.000000000002
R_1_5_0_1 Node1_5_0 Node1_5_1 2.5000000000000004
Rsp_1_5_0_1 Node1_5_0 Node_sp_left 71.54069767441861
R_1_5_0_2 Node1_5_0 Node1_6_0 2.5000000000000004
R_1_5_0_3 Node1_5_0 Node2_5_0 10240.000000000002
R_1_5_1_1 Node1_5_1 Node1_5_2 2.5000000000000004
R_1_5_1_2 Node1_5_1 Node1_6_1 2.5000000000000004
R_1_5_1_3 Node1_5_1 Node2_5_1 10240.000000000002
R_1_5_2_1 Node1_5_2 Node1_5_3 2.5000000000000004
R_1_5_2_2 Node1_5_2 Node1_6_2 2.5000000000000004
R_1_5_2_3 Node1_5_2 Node2_5_2 10240.000000000002
R_1_5_3_1 Node1_5_3 Node1_5_4 2.5000000000000004
R_1_5_3_2 Node1_5_3 Node1_6_3 2.5000000000000004
R_1_5_3_3 Node1_5_3 Node2_5_3 10240.000000000002
R_1_5_4_1 Node1_5_4 Node1_5_5 2.5000000000000004
R_1_5_4_2 Node1_5_4 Node1_6_4 2.5000000000000004
R_1_5_4_3 Node1_5_4 Node2_5_4 10240.000000000002
R_1_5_5_1 Node1_5_5 Node1_5_6 2.5000000000000004
R_1_5_5_2 Node1_5_5 Node1_6_5 2.5000000000000004
R_1_5_5_3 Node1_5_5 Node2_5_5 10240.000000000002
R_1_5_6_1 Node1_5_6 Node1_5_7 2.5000000000000004
R_1_5_6_2 Node1_5_6 Node1_6_6 2.5000000000000004
R_1_5_6_3 Node1_5_6 Node2_5_6 10240.000000000002
R_1_5_7_1 Node1_5_7 Node1_5_8 2.5000000000000004
R_1_5_7_2 Node1_5_7 Node1_6_7 2.5000000000000004
R_1_5_7_3 Node1_5_7 Node2_5_7 10240.000000000002
R_1_5_8_1 Node1_5_8 Node1_5_9 2.5000000000000004
R_1_5_8_2 Node1_5_8 Node1_6_8 2.5000000000000004
R_1_5_8_3 Node1_5_8 Node2_5_8 10240.000000000002
R_1_5_9_1 Node1_5_9 Node1_5_10 2.5000000000000004
R_1_5_9_2 Node1_5_9 Node1_6_9 2.5000000000000004
R_1_5_9_3 Node1_5_9 Node2_5_9 10240.000000000002
R_1_5_10_1 Node1_5_10 Node1_5_11 2.5000000000000004
R_1_5_10_2 Node1_5_10 Node1_6_10 2.5000000000000004
R_1_5_10_3 Node1_5_10 Node2_5_10 10240.000000000002
R_1_5_11_1 Node1_5_11 Node1_5_12 2.5000000000000004
R_1_5_11_2 Node1_5_11 Node1_6_11 2.5000000000000004
R_1_5_11_3 Node1_5_11 Node2_5_11 10240.000000000002
R_1_5_12_1 Node1_5_12 Node1_5_13 2.5000000000000004
R_1_5_12_2 Node1_5_12 Node1_6_12 2.5000000000000004
R_1_5_12_3 Node1_5_12 Node2_5_12 10240.000000000002
R_1_5_13_1 Node1_5_13 Node1_5_14 2.5000000000000004
R_1_5_13_2 Node1_5_13 Node1_6_13 2.5000000000000004
R_1_5_13_3 Node1_5_13 Node2_5_13 10240.000000000002
R_1_5_14_1 Node1_5_14 Node1_5_15 2.5000000000000004
R_1_5_14_2 Node1_5_14 Node1_6_14 2.5000000000000004
R_1_5_14_3 Node1_5_14 Node2_5_14 10240.000000000002
R_1_5_15_1 Node1_5_15 Node1_5_16 2.5000000000000004
R_1_5_15_2 Node1_5_15 Node1_6_15 2.5000000000000004
R_1_5_15_3 Node1_5_15 Node2_5_15 10240.000000000002
R_1_5_16_1 Node1_5_16 Node1_5_17 2.5000000000000004
R_1_5_16_2 Node1_5_16 Node1_6_16 2.5000000000000004
R_1_5_16_3 Node1_5_16 Node2_5_16 10240.000000000002
R_1_5_17_1 Node1_5_17 Node1_5_18 2.5000000000000004
R_1_5_17_2 Node1_5_17 Node1_6_17 2.5000000000000004
R_1_5_17_3 Node1_5_17 Node2_5_17 10240.000000000002
R_1_5_18_1 Node1_5_18 Node1_5_19 2.5000000000000004
R_1_5_18_2 Node1_5_18 Node1_6_18 2.5000000000000004
R_1_5_18_3 Node1_5_18 Node2_5_18 10240.000000000002
R_1_5_19_1 Node1_5_19 Node1_5_20 2.5000000000000004
R_1_5_19_2 Node1_5_19 Node1_6_19 2.5000000000000004
R_1_5_19_3 Node1_5_19 Node2_5_19 10240.000000000002
R_1_5_20_1 Node1_5_20 Node1_5_21 2.5000000000000004
R_1_5_20_2 Node1_5_20 Node1_6_20 2.5000000000000004
R_1_5_20_3 Node1_5_20 Node2_5_20 10240.000000000002
R_1_5_21_1 Node1_5_21 Node1_5_22 2.5000000000000004
R_1_5_21_2 Node1_5_21 Node1_6_21 2.5000000000000004
R_1_5_21_3 Node1_5_21 Node2_5_21 10240.000000000002
R_1_5_22_1 Node1_5_22 Node1_5_23 2.5000000000000004
R_1_5_22_2 Node1_5_22 Node1_6_22 2.5000000000000004
R_1_5_22_3 Node1_5_22 Node2_5_22 10240.000000000002
R_1_5_23_1 Node1_5_23 Node1_5_24 2.5000000000000004
R_1_5_23_2 Node1_5_23 Node1_6_23 2.5000000000000004
R_1_5_23_3 Node1_5_23 Node2_5_23 10240.000000000002
R_1_5_24_1 Node1_5_24 Node1_5_25 2.5000000000000004
R_1_5_24_2 Node1_5_24 Node1_6_24 2.5000000000000004
R_1_5_24_3 Node1_5_24 Node2_5_24 10240.000000000002
R_1_5_25_1 Node1_5_25 Node1_5_26 2.5000000000000004
R_1_5_25_2 Node1_5_25 Node1_6_25 2.5000000000000004
R_1_5_25_3 Node1_5_25 Node2_5_25 10240.000000000002
R_1_5_26_1 Node1_5_26 Node1_5_27 2.5000000000000004
R_1_5_26_2 Node1_5_26 Node1_6_26 2.5000000000000004
R_1_5_26_3 Node1_5_26 Node2_5_26 10240.000000000002
R_1_5_27_1 Node1_5_27 Node1_5_28 2.5000000000000004
R_1_5_27_2 Node1_5_27 Node1_6_27 2.5000000000000004
R_1_5_27_3 Node1_5_27 Node2_5_27 10240.000000000002
R_1_5_28_1 Node1_5_28 Node1_5_29 2.5000000000000004
R_1_5_28_2 Node1_5_28 Node1_6_28 2.5000000000000004
R_1_5_28_3 Node1_5_28 Node2_5_28 10240.000000000002
R_1_5_29_1 Node1_5_29 Node1_5_30 2.5000000000000004
R_1_5_29_2 Node1_5_29 Node1_6_29 2.5000000000000004
R_1_5_29_3 Node1_5_29 Node2_5_29 10240.000000000002
R_1_5_30_1 Node1_5_30 Node1_5_31 2.5000000000000004
R_1_5_30_2 Node1_5_30 Node1_6_30 2.5000000000000004
R_1_5_30_3 Node1_5_30 Node2_5_30 10240.000000000002
Rsp_1_5_31_1 Node1_5_31 Node_sp_right 71.54069767441861
R_1_5_31_2 Node1_5_31 Node1_6_31 2.5000000000000004
R_1_5_31_3 Node1_5_31 Node2_5_31 10240.000000000002
R_1_6_0_1 Node1_6_0 Node1_6_1 2.5000000000000004
Rsp_1_6_0_1 Node1_6_0 Node_sp_left 71.54069767441861
R_1_6_0_2 Node1_6_0 Node1_7_0 2.5000000000000004
R_1_6_0_3 Node1_6_0 Node2_6_0 10240.000000000002
R_1_6_1_1 Node1_6_1 Node1_6_2 2.5000000000000004
R_1_6_1_2 Node1_6_1 Node1_7_1 2.5000000000000004
R_1_6_1_3 Node1_6_1 Node2_6_1 10240.000000000002
R_1_6_2_1 Node1_6_2 Node1_6_3 2.5000000000000004
R_1_6_2_2 Node1_6_2 Node1_7_2 2.5000000000000004
R_1_6_2_3 Node1_6_2 Node2_6_2 10240.000000000002
R_1_6_3_1 Node1_6_3 Node1_6_4 2.5000000000000004
R_1_6_3_2 Node1_6_3 Node1_7_3 2.5000000000000004
R_1_6_3_3 Node1_6_3 Node2_6_3 10240.000000000002
R_1_6_4_1 Node1_6_4 Node1_6_5 2.5000000000000004
R_1_6_4_2 Node1_6_4 Node1_7_4 2.5000000000000004
R_1_6_4_3 Node1_6_4 Node2_6_4 10240.000000000002
R_1_6_5_1 Node1_6_5 Node1_6_6 2.5000000000000004
R_1_6_5_2 Node1_6_5 Node1_7_5 2.5000000000000004
R_1_6_5_3 Node1_6_5 Node2_6_5 10240.000000000002
R_1_6_6_1 Node1_6_6 Node1_6_7 2.5000000000000004
R_1_6_6_2 Node1_6_6 Node1_7_6 2.5000000000000004
R_1_6_6_3 Node1_6_6 Node2_6_6 10240.000000000002
R_1_6_7_1 Node1_6_7 Node1_6_8 2.5000000000000004
R_1_6_7_2 Node1_6_7 Node1_7_7 2.5000000000000004
R_1_6_7_3 Node1_6_7 Node2_6_7 10240.000000000002
R_1_6_8_1 Node1_6_8 Node1_6_9 2.5000000000000004
R_1_6_8_2 Node1_6_8 Node1_7_8 2.5000000000000004
R_1_6_8_3 Node1_6_8 Node2_6_8 10240.000000000002
R_1_6_9_1 Node1_6_9 Node1_6_10 2.5000000000000004
R_1_6_9_2 Node1_6_9 Node1_7_9 2.5000000000000004
R_1_6_9_3 Node1_6_9 Node2_6_9 10240.000000000002
R_1_6_10_1 Node1_6_10 Node1_6_11 2.5000000000000004
R_1_6_10_2 Node1_6_10 Node1_7_10 2.5000000000000004
R_1_6_10_3 Node1_6_10 Node2_6_10 10240.000000000002
R_1_6_11_1 Node1_6_11 Node1_6_12 2.5000000000000004
R_1_6_11_2 Node1_6_11 Node1_7_11 2.5000000000000004
R_1_6_11_3 Node1_6_11 Node2_6_11 10240.000000000002
R_1_6_12_1 Node1_6_12 Node1_6_13 2.5000000000000004
R_1_6_12_2 Node1_6_12 Node1_7_12 2.5000000000000004
R_1_6_12_3 Node1_6_12 Node2_6_12 10240.000000000002
R_1_6_13_1 Node1_6_13 Node1_6_14 2.5000000000000004
R_1_6_13_2 Node1_6_13 Node1_7_13 2.5000000000000004
R_1_6_13_3 Node1_6_13 Node2_6_13 10240.000000000002
R_1_6_14_1 Node1_6_14 Node1_6_15 2.5000000000000004
R_1_6_14_2 Node1_6_14 Node1_7_14 2.5000000000000004
R_1_6_14_3 Node1_6_14 Node2_6_14 10240.000000000002
R_1_6_15_1 Node1_6_15 Node1_6_16 2.5000000000000004
R_1_6_15_2 Node1_6_15 Node1_7_15 2.5000000000000004
R_1_6_15_3 Node1_6_15 Node2_6_15 10240.000000000002
R_1_6_16_1 Node1_6_16 Node1_6_17 2.5000000000000004
R_1_6_16_2 Node1_6_16 Node1_7_16 2.5000000000000004
R_1_6_16_3 Node1_6_16 Node2_6_16 10240.000000000002
R_1_6_17_1 Node1_6_17 Node1_6_18 2.5000000000000004
R_1_6_17_2 Node1_6_17 Node1_7_17 2.5000000000000004
R_1_6_17_3 Node1_6_17 Node2_6_17 10240.000000000002
R_1_6_18_1 Node1_6_18 Node1_6_19 2.5000000000000004
R_1_6_18_2 Node1_6_18 Node1_7_18 2.5000000000000004
R_1_6_18_3 Node1_6_18 Node2_6_18 10240.000000000002
R_1_6_19_1 Node1_6_19 Node1_6_20 2.5000000000000004
R_1_6_19_2 Node1_6_19 Node1_7_19 2.5000000000000004
R_1_6_19_3 Node1_6_19 Node2_6_19 10240.000000000002
R_1_6_20_1 Node1_6_20 Node1_6_21 2.5000000000000004
R_1_6_20_2 Node1_6_20 Node1_7_20 2.5000000000000004
R_1_6_20_3 Node1_6_20 Node2_6_20 10240.000000000002
R_1_6_21_1 Node1_6_21 Node1_6_22 2.5000000000000004
R_1_6_21_2 Node1_6_21 Node1_7_21 2.5000000000000004
R_1_6_21_3 Node1_6_21 Node2_6_21 10240.000000000002
R_1_6_22_1 Node1_6_22 Node1_6_23 2.5000000000000004
R_1_6_22_2 Node1_6_22 Node1_7_22 2.5000000000000004
R_1_6_22_3 Node1_6_22 Node2_6_22 10240.000000000002
R_1_6_23_1 Node1_6_23 Node1_6_24 2.5000000000000004
R_1_6_23_2 Node1_6_23 Node1_7_23 2.5000000000000004
R_1_6_23_3 Node1_6_23 Node2_6_23 10240.000000000002
R_1_6_24_1 Node1_6_24 Node1_6_25 2.5000000000000004
R_1_6_24_2 Node1_6_24 Node1_7_24 2.5000000000000004
R_1_6_24_3 Node1_6_24 Node2_6_24 10240.000000000002
R_1_6_25_1 Node1_6_25 Node1_6_26 2.5000000000000004
R_1_6_25_2 Node1_6_25 Node1_7_25 2.5000000000000004
R_1_6_25_3 Node1_6_25 Node2_6_25 10240.000000000002
R_1_6_26_1 Node1_6_26 Node1_6_27 2.5000000000000004
R_1_6_26_2 Node1_6_26 Node1_7_26 2.5000000000000004
R_1_6_26_3 Node1_6_26 Node2_6_26 10240.000000000002
R_1_6_27_1 Node1_6_27 Node1_6_28 2.5000000000000004
R_1_6_27_2 Node1_6_27 Node1_7_27 2.5000000000000004
R_1_6_27_3 Node1_6_27 Node2_6_27 10240.000000000002
R_1_6_28_1 Node1_6_28 Node1_6_29 2.5000000000000004
R_1_6_28_2 Node1_6_28 Node1_7_28 2.5000000000000004
R_1_6_28_3 Node1_6_28 Node2_6_28 10240.000000000002
R_1_6_29_1 Node1_6_29 Node1_6_30 2.5000000000000004
R_1_6_29_2 Node1_6_29 Node1_7_29 2.5000000000000004
R_1_6_29_3 Node1_6_29 Node2_6_29 10240.000000000002
R_1_6_30_1 Node1_6_30 Node1_6_31 2.5000000000000004
R_1_6_30_2 Node1_6_30 Node1_7_30 2.5000000000000004
R_1_6_30_3 Node1_6_30 Node2_6_30 10240.000000000002
Rsp_1_6_31_1 Node1_6_31 Node_sp_right 71.54069767441861
R_1_6_31_2 Node1_6_31 Node1_7_31 2.5000000000000004
R_1_6_31_3 Node1_6_31 Node2_6_31 10240.000000000002
R_1_7_0_1 Node1_7_0 Node1_7_1 2.5000000000000004
Rsp_1_7_0_1 Node1_7_0 Node_sp_left 71.54069767441861
R_1_7_0_2 Node1_7_0 Node1_8_0 2.5000000000000004
R_1_7_0_3 Node1_7_0 Node2_7_0 10240.000000000002
R_1_7_1_1 Node1_7_1 Node1_7_2 2.5000000000000004
R_1_7_1_2 Node1_7_1 Node1_8_1 2.5000000000000004
R_1_7_1_3 Node1_7_1 Node2_7_1 10240.000000000002
R_1_7_2_1 Node1_7_2 Node1_7_3 2.5000000000000004
R_1_7_2_2 Node1_7_2 Node1_8_2 2.5000000000000004
R_1_7_2_3 Node1_7_2 Node2_7_2 10240.000000000002
R_1_7_3_1 Node1_7_3 Node1_7_4 2.5000000000000004
R_1_7_3_2 Node1_7_3 Node1_8_3 2.5000000000000004
R_1_7_3_3 Node1_7_3 Node2_7_3 10240.000000000002
R_1_7_4_1 Node1_7_4 Node1_7_5 2.5000000000000004
R_1_7_4_2 Node1_7_4 Node1_8_4 2.5000000000000004
R_1_7_4_3 Node1_7_4 Node2_7_4 10240.000000000002
R_1_7_5_1 Node1_7_5 Node1_7_6 2.5000000000000004
R_1_7_5_2 Node1_7_5 Node1_8_5 2.5000000000000004
R_1_7_5_3 Node1_7_5 Node2_7_5 10240.000000000002
R_1_7_6_1 Node1_7_6 Node1_7_7 2.5000000000000004
R_1_7_6_2 Node1_7_6 Node1_8_6 2.5000000000000004
R_1_7_6_3 Node1_7_6 Node2_7_6 10240.000000000002
R_1_7_7_1 Node1_7_7 Node1_7_8 2.5000000000000004
R_1_7_7_2 Node1_7_7 Node1_8_7 2.5000000000000004
R_1_7_7_3 Node1_7_7 Node2_7_7 10240.000000000002
R_1_7_8_1 Node1_7_8 Node1_7_9 2.5000000000000004
R_1_7_8_2 Node1_7_8 Node1_8_8 2.5000000000000004
R_1_7_8_3 Node1_7_8 Node2_7_8 10240.000000000002
R_1_7_9_1 Node1_7_9 Node1_7_10 2.5000000000000004
R_1_7_9_2 Node1_7_9 Node1_8_9 2.5000000000000004
R_1_7_9_3 Node1_7_9 Node2_7_9 10240.000000000002
R_1_7_10_1 Node1_7_10 Node1_7_11 2.5000000000000004
R_1_7_10_2 Node1_7_10 Node1_8_10 2.5000000000000004
R_1_7_10_3 Node1_7_10 Node2_7_10 10240.000000000002
R_1_7_11_1 Node1_7_11 Node1_7_12 2.5000000000000004
R_1_7_11_2 Node1_7_11 Node1_8_11 2.5000000000000004
R_1_7_11_3 Node1_7_11 Node2_7_11 10240.000000000002
R_1_7_12_1 Node1_7_12 Node1_7_13 2.5000000000000004
R_1_7_12_2 Node1_7_12 Node1_8_12 2.5000000000000004
R_1_7_12_3 Node1_7_12 Node2_7_12 10240.000000000002
R_1_7_13_1 Node1_7_13 Node1_7_14 2.5000000000000004
R_1_7_13_2 Node1_7_13 Node1_8_13 2.5000000000000004
R_1_7_13_3 Node1_7_13 Node2_7_13 10240.000000000002
R_1_7_14_1 Node1_7_14 Node1_7_15 2.5000000000000004
R_1_7_14_2 Node1_7_14 Node1_8_14 2.5000000000000004
R_1_7_14_3 Node1_7_14 Node2_7_14 10240.000000000002
R_1_7_15_1 Node1_7_15 Node1_7_16 2.5000000000000004
R_1_7_15_2 Node1_7_15 Node1_8_15 2.5000000000000004
R_1_7_15_3 Node1_7_15 Node2_7_15 10240.000000000002
R_1_7_16_1 Node1_7_16 Node1_7_17 2.5000000000000004
R_1_7_16_2 Node1_7_16 Node1_8_16 2.5000000000000004
R_1_7_16_3 Node1_7_16 Node2_7_16 10240.000000000002
R_1_7_17_1 Node1_7_17 Node1_7_18 2.5000000000000004
R_1_7_17_2 Node1_7_17 Node1_8_17 2.5000000000000004
R_1_7_17_3 Node1_7_17 Node2_7_17 10240.000000000002
R_1_7_18_1 Node1_7_18 Node1_7_19 2.5000000000000004
R_1_7_18_2 Node1_7_18 Node1_8_18 2.5000000000000004
R_1_7_18_3 Node1_7_18 Node2_7_18 10240.000000000002
R_1_7_19_1 Node1_7_19 Node1_7_20 2.5000000000000004
R_1_7_19_2 Node1_7_19 Node1_8_19 2.5000000000000004
R_1_7_19_3 Node1_7_19 Node2_7_19 10240.000000000002
R_1_7_20_1 Node1_7_20 Node1_7_21 2.5000000000000004
R_1_7_20_2 Node1_7_20 Node1_8_20 2.5000000000000004
R_1_7_20_3 Node1_7_20 Node2_7_20 10240.000000000002
R_1_7_21_1 Node1_7_21 Node1_7_22 2.5000000000000004
R_1_7_21_2 Node1_7_21 Node1_8_21 2.5000000000000004
R_1_7_21_3 Node1_7_21 Node2_7_21 10240.000000000002
R_1_7_22_1 Node1_7_22 Node1_7_23 2.5000000000000004
R_1_7_22_2 Node1_7_22 Node1_8_22 2.5000000000000004
R_1_7_22_3 Node1_7_22 Node2_7_22 10240.000000000002
R_1_7_23_1 Node1_7_23 Node1_7_24 2.5000000000000004
R_1_7_23_2 Node1_7_23 Node1_8_23 2.5000000000000004
R_1_7_23_3 Node1_7_23 Node2_7_23 10240.000000000002
R_1_7_24_1 Node1_7_24 Node1_7_25 2.5000000000000004
R_1_7_24_2 Node1_7_24 Node1_8_24 2.5000000000000004
R_1_7_24_3 Node1_7_24 Node2_7_24 10240.000000000002
R_1_7_25_1 Node1_7_25 Node1_7_26 2.5000000000000004
R_1_7_25_2 Node1_7_25 Node1_8_25 2.5000000000000004
R_1_7_25_3 Node1_7_25 Node2_7_25 10240.000000000002
R_1_7_26_1 Node1_7_26 Node1_7_27 2.5000000000000004
R_1_7_26_2 Node1_7_26 Node1_8_26 2.5000000000000004
R_1_7_26_3 Node1_7_26 Node2_7_26 10240.000000000002
R_1_7_27_1 Node1_7_27 Node1_7_28 2.5000000000000004
R_1_7_27_2 Node1_7_27 Node1_8_27 2.5000000000000004
R_1_7_27_3 Node1_7_27 Node2_7_27 10240.000000000002
R_1_7_28_1 Node1_7_28 Node1_7_29 2.5000000000000004
R_1_7_28_2 Node1_7_28 Node1_8_28 2.5000000000000004
R_1_7_28_3 Node1_7_28 Node2_7_28 10240.000000000002
R_1_7_29_1 Node1_7_29 Node1_7_30 2.5000000000000004
R_1_7_29_2 Node1_7_29 Node1_8_29 2.5000000000000004
R_1_7_29_3 Node1_7_29 Node2_7_29 10240.000000000002
R_1_7_30_1 Node1_7_30 Node1_7_31 2.5000000000000004
R_1_7_30_2 Node1_7_30 Node1_8_30 2.5000000000000004
R_1_7_30_3 Node1_7_30 Node2_7_30 10240.000000000002
Rsp_1_7_31_1 Node1_7_31 Node_sp_right 71.54069767441861
R_1_7_31_2 Node1_7_31 Node1_8_31 2.5000000000000004
R_1_7_31_3 Node1_7_31 Node2_7_31 10240.000000000002
R_1_8_0_1 Node1_8_0 Node1_8_1 2.5000000000000004
Rsp_1_8_0_1 Node1_8_0 Node_sp_left 71.54069767441861
R_1_8_0_2 Node1_8_0 Node1_9_0 2.5000000000000004
R_1_8_0_3 Node1_8_0 Node2_8_0 10240.000000000002
R_1_8_1_1 Node1_8_1 Node1_8_2 2.5000000000000004
R_1_8_1_2 Node1_8_1 Node1_9_1 2.5000000000000004
R_1_8_1_3 Node1_8_1 Node2_8_1 10240.000000000002
R_1_8_2_1 Node1_8_2 Node1_8_3 2.5000000000000004
R_1_8_2_2 Node1_8_2 Node1_9_2 2.5000000000000004
R_1_8_2_3 Node1_8_2 Node2_8_2 10240.000000000002
R_1_8_3_1 Node1_8_3 Node1_8_4 2.5000000000000004
R_1_8_3_2 Node1_8_3 Node1_9_3 2.5000000000000004
R_1_8_3_3 Node1_8_3 Node2_8_3 10240.000000000002
R_1_8_4_1 Node1_8_4 Node1_8_5 2.5000000000000004
R_1_8_4_2 Node1_8_4 Node1_9_4 2.5000000000000004
R_1_8_4_3 Node1_8_4 Node2_8_4 10240.000000000002
R_1_8_5_1 Node1_8_5 Node1_8_6 2.5000000000000004
R_1_8_5_2 Node1_8_5 Node1_9_5 2.5000000000000004
R_1_8_5_3 Node1_8_5 Node2_8_5 10240.000000000002
R_1_8_6_1 Node1_8_6 Node1_8_7 2.5000000000000004
R_1_8_6_2 Node1_8_6 Node1_9_6 2.5000000000000004
R_1_8_6_3 Node1_8_6 Node2_8_6 10240.000000000002
R_1_8_7_1 Node1_8_7 Node1_8_8 2.5000000000000004
R_1_8_7_2 Node1_8_7 Node1_9_7 2.5000000000000004
R_1_8_7_3 Node1_8_7 Node2_8_7 10240.000000000002
R_1_8_8_1 Node1_8_8 Node1_8_9 2.5000000000000004
R_1_8_8_2 Node1_8_8 Node1_9_8 2.5000000000000004
R_1_8_8_3 Node1_8_8 Node2_8_8 10240.000000000002
R_1_8_9_1 Node1_8_9 Node1_8_10 2.5000000000000004
R_1_8_9_2 Node1_8_9 Node1_9_9 2.5000000000000004
R_1_8_9_3 Node1_8_9 Node2_8_9 10240.000000000002
R_1_8_10_1 Node1_8_10 Node1_8_11 2.5000000000000004
R_1_8_10_2 Node1_8_10 Node1_9_10 2.5000000000000004
R_1_8_10_3 Node1_8_10 Node2_8_10 10240.000000000002
R_1_8_11_1 Node1_8_11 Node1_8_12 2.5000000000000004
R_1_8_11_2 Node1_8_11 Node1_9_11 2.5000000000000004
R_1_8_11_3 Node1_8_11 Node2_8_11 10240.000000000002
R_1_8_12_1 Node1_8_12 Node1_8_13 2.5000000000000004
R_1_8_12_2 Node1_8_12 Node1_9_12 2.5000000000000004
R_1_8_12_3 Node1_8_12 Node2_8_12 10240.000000000002
R_1_8_13_1 Node1_8_13 Node1_8_14 2.5000000000000004
R_1_8_13_2 Node1_8_13 Node1_9_13 2.5000000000000004
R_1_8_13_3 Node1_8_13 Node2_8_13 10240.000000000002
R_1_8_14_1 Node1_8_14 Node1_8_15 2.5000000000000004
R_1_8_14_2 Node1_8_14 Node1_9_14 2.5000000000000004
R_1_8_14_3 Node1_8_14 Node2_8_14 10240.000000000002
R_1_8_15_1 Node1_8_15 Node1_8_16 2.5000000000000004
R_1_8_15_2 Node1_8_15 Node1_9_15 2.5000000000000004
R_1_8_15_3 Node1_8_15 Node2_8_15 10240.000000000002
R_1_8_16_1 Node1_8_16 Node1_8_17 2.5000000000000004
R_1_8_16_2 Node1_8_16 Node1_9_16 2.5000000000000004
R_1_8_16_3 Node1_8_16 Node2_8_16 10240.000000000002
R_1_8_17_1 Node1_8_17 Node1_8_18 2.5000000000000004
R_1_8_17_2 Node1_8_17 Node1_9_17 2.5000000000000004
R_1_8_17_3 Node1_8_17 Node2_8_17 10240.000000000002
R_1_8_18_1 Node1_8_18 Node1_8_19 2.5000000000000004
R_1_8_18_2 Node1_8_18 Node1_9_18 2.5000000000000004
R_1_8_18_3 Node1_8_18 Node2_8_18 10240.000000000002
R_1_8_19_1 Node1_8_19 Node1_8_20 2.5000000000000004
R_1_8_19_2 Node1_8_19 Node1_9_19 2.5000000000000004
R_1_8_19_3 Node1_8_19 Node2_8_19 10240.000000000002
R_1_8_20_1 Node1_8_20 Node1_8_21 2.5000000000000004
R_1_8_20_2 Node1_8_20 Node1_9_20 2.5000000000000004
R_1_8_20_3 Node1_8_20 Node2_8_20 10240.000000000002
R_1_8_21_1 Node1_8_21 Node1_8_22 2.5000000000000004
R_1_8_21_2 Node1_8_21 Node1_9_21 2.5000000000000004
R_1_8_21_3 Node1_8_21 Node2_8_21 10240.000000000002
R_1_8_22_1 Node1_8_22 Node1_8_23 2.5000000000000004
R_1_8_22_2 Node1_8_22 Node1_9_22 2.5000000000000004
R_1_8_22_3 Node1_8_22 Node2_8_22 10240.000000000002
R_1_8_23_1 Node1_8_23 Node1_8_24 2.5000000000000004
R_1_8_23_2 Node1_8_23 Node1_9_23 2.5000000000000004
R_1_8_23_3 Node1_8_23 Node2_8_23 10240.000000000002
R_1_8_24_1 Node1_8_24 Node1_8_25 2.5000000000000004
R_1_8_24_2 Node1_8_24 Node1_9_24 2.5000000000000004
R_1_8_24_3 Node1_8_24 Node2_8_24 10240.000000000002
R_1_8_25_1 Node1_8_25 Node1_8_26 2.5000000000000004
R_1_8_25_2 Node1_8_25 Node1_9_25 2.5000000000000004
R_1_8_25_3 Node1_8_25 Node2_8_25 10240.000000000002
R_1_8_26_1 Node1_8_26 Node1_8_27 2.5000000000000004
R_1_8_26_2 Node1_8_26 Node1_9_26 2.5000000000000004
R_1_8_26_3 Node1_8_26 Node2_8_26 10240.000000000002
R_1_8_27_1 Node1_8_27 Node1_8_28 2.5000000000000004
R_1_8_27_2 Node1_8_27 Node1_9_27 2.5000000000000004
R_1_8_27_3 Node1_8_27 Node2_8_27 10240.000000000002
R_1_8_28_1 Node1_8_28 Node1_8_29 2.5000000000000004
R_1_8_28_2 Node1_8_28 Node1_9_28 2.5000000000000004
R_1_8_28_3 Node1_8_28 Node2_8_28 10240.000000000002
R_1_8_29_1 Node1_8_29 Node1_8_30 2.5000000000000004
R_1_8_29_2 Node1_8_29 Node1_9_29 2.5000000000000004
R_1_8_29_3 Node1_8_29 Node2_8_29 10240.000000000002
R_1_8_30_1 Node1_8_30 Node1_8_31 2.5000000000000004
R_1_8_30_2 Node1_8_30 Node1_9_30 2.5000000000000004
R_1_8_30_3 Node1_8_30 Node2_8_30 10240.000000000002
Rsp_1_8_31_1 Node1_8_31 Node_sp_right 71.54069767441861
R_1_8_31_2 Node1_8_31 Node1_9_31 2.5000000000000004
R_1_8_31_3 Node1_8_31 Node2_8_31 10240.000000000002
R_1_9_0_1 Node1_9_0 Node1_9_1 2.5000000000000004
Rsp_1_9_0_1 Node1_9_0 Node_sp_left 71.54069767441861
R_1_9_0_2 Node1_9_0 Node1_10_0 2.5000000000000004
R_1_9_0_3 Node1_9_0 Node2_9_0 10240.000000000002
R_1_9_1_1 Node1_9_1 Node1_9_2 2.5000000000000004
R_1_9_1_2 Node1_9_1 Node1_10_1 2.5000000000000004
R_1_9_1_3 Node1_9_1 Node2_9_1 10240.000000000002
R_1_9_2_1 Node1_9_2 Node1_9_3 2.5000000000000004
R_1_9_2_2 Node1_9_2 Node1_10_2 2.5000000000000004
R_1_9_2_3 Node1_9_2 Node2_9_2 10240.000000000002
R_1_9_3_1 Node1_9_3 Node1_9_4 2.5000000000000004
R_1_9_3_2 Node1_9_3 Node1_10_3 2.5000000000000004
R_1_9_3_3 Node1_9_3 Node2_9_3 10240.000000000002
R_1_9_4_1 Node1_9_4 Node1_9_5 2.5000000000000004
R_1_9_4_2 Node1_9_4 Node1_10_4 2.5000000000000004
R_1_9_4_3 Node1_9_4 Node2_9_4 10240.000000000002
R_1_9_5_1 Node1_9_5 Node1_9_6 2.5000000000000004
R_1_9_5_2 Node1_9_5 Node1_10_5 2.5000000000000004
R_1_9_5_3 Node1_9_5 Node2_9_5 10240.000000000002
R_1_9_6_1 Node1_9_6 Node1_9_7 2.5000000000000004
R_1_9_6_2 Node1_9_6 Node1_10_6 2.5000000000000004
R_1_9_6_3 Node1_9_6 Node2_9_6 10240.000000000002
R_1_9_7_1 Node1_9_7 Node1_9_8 2.5000000000000004
R_1_9_7_2 Node1_9_7 Node1_10_7 2.5000000000000004
R_1_9_7_3 Node1_9_7 Node2_9_7 10240.000000000002
R_1_9_8_1 Node1_9_8 Node1_9_9 2.5000000000000004
R_1_9_8_2 Node1_9_8 Node1_10_8 2.5000000000000004
R_1_9_8_3 Node1_9_8 Node2_9_8 10240.000000000002
R_1_9_9_1 Node1_9_9 Node1_9_10 2.5000000000000004
R_1_9_9_2 Node1_9_9 Node1_10_9 2.5000000000000004
R_1_9_9_3 Node1_9_9 Node2_9_9 10240.000000000002
R_1_9_10_1 Node1_9_10 Node1_9_11 2.5000000000000004
R_1_9_10_2 Node1_9_10 Node1_10_10 2.5000000000000004
R_1_9_10_3 Node1_9_10 Node2_9_10 10240.000000000002
R_1_9_11_1 Node1_9_11 Node1_9_12 2.5000000000000004
R_1_9_11_2 Node1_9_11 Node1_10_11 2.5000000000000004
R_1_9_11_3 Node1_9_11 Node2_9_11 10240.000000000002
R_1_9_12_1 Node1_9_12 Node1_9_13 2.5000000000000004
R_1_9_12_2 Node1_9_12 Node1_10_12 2.5000000000000004
R_1_9_12_3 Node1_9_12 Node2_9_12 10240.000000000002
R_1_9_13_1 Node1_9_13 Node1_9_14 2.5000000000000004
R_1_9_13_2 Node1_9_13 Node1_10_13 2.5000000000000004
R_1_9_13_3 Node1_9_13 Node2_9_13 10240.000000000002
R_1_9_14_1 Node1_9_14 Node1_9_15 2.5000000000000004
R_1_9_14_2 Node1_9_14 Node1_10_14 2.5000000000000004
R_1_9_14_3 Node1_9_14 Node2_9_14 10240.000000000002
R_1_9_15_1 Node1_9_15 Node1_9_16 2.5000000000000004
R_1_9_15_2 Node1_9_15 Node1_10_15 2.5000000000000004
R_1_9_15_3 Node1_9_15 Node2_9_15 10240.000000000002
R_1_9_16_1 Node1_9_16 Node1_9_17 2.5000000000000004
R_1_9_16_2 Node1_9_16 Node1_10_16 2.5000000000000004
R_1_9_16_3 Node1_9_16 Node2_9_16 10240.000000000002
R_1_9_17_1 Node1_9_17 Node1_9_18 2.5000000000000004
R_1_9_17_2 Node1_9_17 Node1_10_17 2.5000000000000004
R_1_9_17_3 Node1_9_17 Node2_9_17 10240.000000000002
R_1_9_18_1 Node1_9_18 Node1_9_19 2.5000000000000004
R_1_9_18_2 Node1_9_18 Node1_10_18 2.5000000000000004
R_1_9_18_3 Node1_9_18 Node2_9_18 10240.000000000002
R_1_9_19_1 Node1_9_19 Node1_9_20 2.5000000000000004
R_1_9_19_2 Node1_9_19 Node1_10_19 2.5000000000000004
R_1_9_19_3 Node1_9_19 Node2_9_19 10240.000000000002
R_1_9_20_1 Node1_9_20 Node1_9_21 2.5000000000000004
R_1_9_20_2 Node1_9_20 Node1_10_20 2.5000000000000004
R_1_9_20_3 Node1_9_20 Node2_9_20 10240.000000000002
R_1_9_21_1 Node1_9_21 Node1_9_22 2.5000000000000004
R_1_9_21_2 Node1_9_21 Node1_10_21 2.5000000000000004
R_1_9_21_3 Node1_9_21 Node2_9_21 10240.000000000002
R_1_9_22_1 Node1_9_22 Node1_9_23 2.5000000000000004
R_1_9_22_2 Node1_9_22 Node1_10_22 2.5000000000000004
R_1_9_22_3 Node1_9_22 Node2_9_22 10240.000000000002
R_1_9_23_1 Node1_9_23 Node1_9_24 2.5000000000000004
R_1_9_23_2 Node1_9_23 Node1_10_23 2.5000000000000004
R_1_9_23_3 Node1_9_23 Node2_9_23 10240.000000000002
R_1_9_24_1 Node1_9_24 Node1_9_25 2.5000000000000004
R_1_9_24_2 Node1_9_24 Node1_10_24 2.5000000000000004
R_1_9_24_3 Node1_9_24 Node2_9_24 10240.000000000002
R_1_9_25_1 Node1_9_25 Node1_9_26 2.5000000000000004
R_1_9_25_2 Node1_9_25 Node1_10_25 2.5000000000000004
R_1_9_25_3 Node1_9_25 Node2_9_25 10240.000000000002
R_1_9_26_1 Node1_9_26 Node1_9_27 2.5000000000000004
R_1_9_26_2 Node1_9_26 Node1_10_26 2.5000000000000004
R_1_9_26_3 Node1_9_26 Node2_9_26 10240.000000000002
R_1_9_27_1 Node1_9_27 Node1_9_28 2.5000000000000004
R_1_9_27_2 Node1_9_27 Node1_10_27 2.5000000000000004
R_1_9_27_3 Node1_9_27 Node2_9_27 10240.000000000002
R_1_9_28_1 Node1_9_28 Node1_9_29 2.5000000000000004
R_1_9_28_2 Node1_9_28 Node1_10_28 2.5000000000000004
R_1_9_28_3 Node1_9_28 Node2_9_28 10240.000000000002
R_1_9_29_1 Node1_9_29 Node1_9_30 2.5000000000000004
R_1_9_29_2 Node1_9_29 Node1_10_29 2.5000000000000004
R_1_9_29_3 Node1_9_29 Node2_9_29 10240.000000000002
R_1_9_30_1 Node1_9_30 Node1_9_31 2.5000000000000004
R_1_9_30_2 Node1_9_30 Node1_10_30 2.5000000000000004
R_1_9_30_3 Node1_9_30 Node2_9_30 10240.000000000002
Rsp_1_9_31_1 Node1_9_31 Node_sp_right 71.54069767441861
R_1_9_31_2 Node1_9_31 Node1_10_31 2.5000000000000004
R_1_9_31_3 Node1_9_31 Node2_9_31 10240.000000000002
R_1_10_0_1 Node1_10_0 Node1_10_1 2.5000000000000004
Rsp_1_10_0_1 Node1_10_0 Node_sp_left 71.54069767441861
R_1_10_0_2 Node1_10_0 Node1_11_0 2.5000000000000004
R_1_10_0_3 Node1_10_0 Node2_10_0 10240.000000000002
R_1_10_1_1 Node1_10_1 Node1_10_2 2.5000000000000004
R_1_10_1_2 Node1_10_1 Node1_11_1 2.5000000000000004
R_1_10_1_3 Node1_10_1 Node2_10_1 10240.000000000002
R_1_10_2_1 Node1_10_2 Node1_10_3 2.5000000000000004
R_1_10_2_2 Node1_10_2 Node1_11_2 2.5000000000000004
R_1_10_2_3 Node1_10_2 Node2_10_2 10240.000000000002
R_1_10_3_1 Node1_10_3 Node1_10_4 2.5000000000000004
R_1_10_3_2 Node1_10_3 Node1_11_3 2.5000000000000004
R_1_10_3_3 Node1_10_3 Node2_10_3 10240.000000000002
R_1_10_4_1 Node1_10_4 Node1_10_5 2.5000000000000004
R_1_10_4_2 Node1_10_4 Node1_11_4 2.5000000000000004
R_1_10_4_3 Node1_10_4 Node2_10_4 10240.000000000002
R_1_10_5_1 Node1_10_5 Node1_10_6 2.5000000000000004
R_1_10_5_2 Node1_10_5 Node1_11_5 2.5000000000000004
R_1_10_5_3 Node1_10_5 Node2_10_5 10240.000000000002
R_1_10_6_1 Node1_10_6 Node1_10_7 2.5000000000000004
R_1_10_6_2 Node1_10_6 Node1_11_6 2.5000000000000004
R_1_10_6_3 Node1_10_6 Node2_10_6 10240.000000000002
R_1_10_7_1 Node1_10_7 Node1_10_8 2.5000000000000004
R_1_10_7_2 Node1_10_7 Node1_11_7 2.5000000000000004
R_1_10_7_3 Node1_10_7 Node2_10_7 10240.000000000002
R_1_10_8_1 Node1_10_8 Node1_10_9 2.5000000000000004
R_1_10_8_2 Node1_10_8 Node1_11_8 2.5000000000000004
R_1_10_8_3 Node1_10_8 Node2_10_8 10240.000000000002
R_1_10_9_1 Node1_10_9 Node1_10_10 2.5000000000000004
R_1_10_9_2 Node1_10_9 Node1_11_9 2.5000000000000004
R_1_10_9_3 Node1_10_9 Node2_10_9 10240.000000000002
R_1_10_10_1 Node1_10_10 Node1_10_11 2.5000000000000004
R_1_10_10_2 Node1_10_10 Node1_11_10 2.5000000000000004
R_1_10_10_3 Node1_10_10 Node2_10_10 10240.000000000002
R_1_10_11_1 Node1_10_11 Node1_10_12 2.5000000000000004
R_1_10_11_2 Node1_10_11 Node1_11_11 2.5000000000000004
R_1_10_11_3 Node1_10_11 Node2_10_11 10240.000000000002
R_1_10_12_1 Node1_10_12 Node1_10_13 2.5000000000000004
R_1_10_12_2 Node1_10_12 Node1_11_12 2.5000000000000004
R_1_10_12_3 Node1_10_12 Node2_10_12 10240.000000000002
R_1_10_13_1 Node1_10_13 Node1_10_14 2.5000000000000004
R_1_10_13_2 Node1_10_13 Node1_11_13 2.5000000000000004
R_1_10_13_3 Node1_10_13 Node2_10_13 10240.000000000002
R_1_10_14_1 Node1_10_14 Node1_10_15 2.5000000000000004
R_1_10_14_2 Node1_10_14 Node1_11_14 2.5000000000000004
R_1_10_14_3 Node1_10_14 Node2_10_14 10240.000000000002
R_1_10_15_1 Node1_10_15 Node1_10_16 2.5000000000000004
R_1_10_15_2 Node1_10_15 Node1_11_15 2.5000000000000004
R_1_10_15_3 Node1_10_15 Node2_10_15 10240.000000000002
R_1_10_16_1 Node1_10_16 Node1_10_17 2.5000000000000004
R_1_10_16_2 Node1_10_16 Node1_11_16 2.5000000000000004
R_1_10_16_3 Node1_10_16 Node2_10_16 10240.000000000002
R_1_10_17_1 Node1_10_17 Node1_10_18 2.5000000000000004
R_1_10_17_2 Node1_10_17 Node1_11_17 2.5000000000000004
R_1_10_17_3 Node1_10_17 Node2_10_17 10240.000000000002
R_1_10_18_1 Node1_10_18 Node1_10_19 2.5000000000000004
R_1_10_18_2 Node1_10_18 Node1_11_18 2.5000000000000004
R_1_10_18_3 Node1_10_18 Node2_10_18 10240.000000000002
R_1_10_19_1 Node1_10_19 Node1_10_20 2.5000000000000004
R_1_10_19_2 Node1_10_19 Node1_11_19 2.5000000000000004
R_1_10_19_3 Node1_10_19 Node2_10_19 10240.000000000002
R_1_10_20_1 Node1_10_20 Node1_10_21 2.5000000000000004
R_1_10_20_2 Node1_10_20 Node1_11_20 2.5000000000000004
R_1_10_20_3 Node1_10_20 Node2_10_20 10240.000000000002
R_1_10_21_1 Node1_10_21 Node1_10_22 2.5000000000000004
R_1_10_21_2 Node1_10_21 Node1_11_21 2.5000000000000004
R_1_10_21_3 Node1_10_21 Node2_10_21 10240.000000000002
R_1_10_22_1 Node1_10_22 Node1_10_23 2.5000000000000004
R_1_10_22_2 Node1_10_22 Node1_11_22 2.5000000000000004
R_1_10_22_3 Node1_10_22 Node2_10_22 10240.000000000002
R_1_10_23_1 Node1_10_23 Node1_10_24 2.5000000000000004
R_1_10_23_2 Node1_10_23 Node1_11_23 2.5000000000000004
R_1_10_23_3 Node1_10_23 Node2_10_23 10240.000000000002
R_1_10_24_1 Node1_10_24 Node1_10_25 2.5000000000000004
R_1_10_24_2 Node1_10_24 Node1_11_24 2.5000000000000004
R_1_10_24_3 Node1_10_24 Node2_10_24 10240.000000000002
R_1_10_25_1 Node1_10_25 Node1_10_26 2.5000000000000004
R_1_10_25_2 Node1_10_25 Node1_11_25 2.5000000000000004
R_1_10_25_3 Node1_10_25 Node2_10_25 10240.000000000002
R_1_10_26_1 Node1_10_26 Node1_10_27 2.5000000000000004
R_1_10_26_2 Node1_10_26 Node1_11_26 2.5000000000000004
R_1_10_26_3 Node1_10_26 Node2_10_26 10240.000000000002
R_1_10_27_1 Node1_10_27 Node1_10_28 2.5000000000000004
R_1_10_27_2 Node1_10_27 Node1_11_27 2.5000000000000004
R_1_10_27_3 Node1_10_27 Node2_10_27 10240.000000000002
R_1_10_28_1 Node1_10_28 Node1_10_29 2.5000000000000004
R_1_10_28_2 Node1_10_28 Node1_11_28 2.5000000000000004
R_1_10_28_3 Node1_10_28 Node2_10_28 10240.000000000002
R_1_10_29_1 Node1_10_29 Node1_10_30 2.5000000000000004
R_1_10_29_2 Node1_10_29 Node1_11_29 2.5000000000000004
R_1_10_29_3 Node1_10_29 Node2_10_29 10240.000000000002
R_1_10_30_1 Node1_10_30 Node1_10_31 2.5000000000000004
R_1_10_30_2 Node1_10_30 Node1_11_30 2.5000000000000004
R_1_10_30_3 Node1_10_30 Node2_10_30 10240.000000000002
Rsp_1_10_31_1 Node1_10_31 Node_sp_right 71.54069767441861
R_1_10_31_2 Node1_10_31 Node1_11_31 2.5000000000000004
R_1_10_31_3 Node1_10_31 Node2_10_31 10240.000000000002
R_1_11_0_1 Node1_11_0 Node1_11_1 2.5000000000000004
Rsp_1_11_0_1 Node1_11_0 Node_sp_left 71.54069767441861
R_1_11_0_2 Node1_11_0 Node1_12_0 2.5000000000000004
R_1_11_0_3 Node1_11_0 Node2_11_0 10240.000000000002
R_1_11_1_1 Node1_11_1 Node1_11_2 2.5000000000000004
R_1_11_1_2 Node1_11_1 Node1_12_1 2.5000000000000004
R_1_11_1_3 Node1_11_1 Node2_11_1 10240.000000000002
R_1_11_2_1 Node1_11_2 Node1_11_3 2.5000000000000004
R_1_11_2_2 Node1_11_2 Node1_12_2 2.5000000000000004
R_1_11_2_3 Node1_11_2 Node2_11_2 10240.000000000002
R_1_11_3_1 Node1_11_3 Node1_11_4 2.5000000000000004
R_1_11_3_2 Node1_11_3 Node1_12_3 2.5000000000000004
R_1_11_3_3 Node1_11_3 Node2_11_3 10240.000000000002
R_1_11_4_1 Node1_11_4 Node1_11_5 2.5000000000000004
R_1_11_4_2 Node1_11_4 Node1_12_4 2.5000000000000004
R_1_11_4_3 Node1_11_4 Node2_11_4 10240.000000000002
R_1_11_5_1 Node1_11_5 Node1_11_6 2.5000000000000004
R_1_11_5_2 Node1_11_5 Node1_12_5 2.5000000000000004
R_1_11_5_3 Node1_11_5 Node2_11_5 10240.000000000002
R_1_11_6_1 Node1_11_6 Node1_11_7 2.5000000000000004
R_1_11_6_2 Node1_11_6 Node1_12_6 2.5000000000000004
R_1_11_6_3 Node1_11_6 Node2_11_6 10240.000000000002
R_1_11_7_1 Node1_11_7 Node1_11_8 2.5000000000000004
R_1_11_7_2 Node1_11_7 Node1_12_7 2.5000000000000004
R_1_11_7_3 Node1_11_7 Node2_11_7 10240.000000000002
R_1_11_8_1 Node1_11_8 Node1_11_9 2.5000000000000004
R_1_11_8_2 Node1_11_8 Node1_12_8 2.5000000000000004
R_1_11_8_3 Node1_11_8 Node2_11_8 10240.000000000002
R_1_11_9_1 Node1_11_9 Node1_11_10 2.5000000000000004
R_1_11_9_2 Node1_11_9 Node1_12_9 2.5000000000000004
R_1_11_9_3 Node1_11_9 Node2_11_9 10240.000000000002
R_1_11_10_1 Node1_11_10 Node1_11_11 2.5000000000000004
R_1_11_10_2 Node1_11_10 Node1_12_10 2.5000000000000004
R_1_11_10_3 Node1_11_10 Node2_11_10 10240.000000000002
R_1_11_11_1 Node1_11_11 Node1_11_12 2.5000000000000004
R_1_11_11_2 Node1_11_11 Node1_12_11 2.5000000000000004
R_1_11_11_3 Node1_11_11 Node2_11_11 10240.000000000002
R_1_11_12_1 Node1_11_12 Node1_11_13 2.5000000000000004
R_1_11_12_2 Node1_11_12 Node1_12_12 2.5000000000000004
R_1_11_12_3 Node1_11_12 Node2_11_12 10240.000000000002
R_1_11_13_1 Node1_11_13 Node1_11_14 2.5000000000000004
R_1_11_13_2 Node1_11_13 Node1_12_13 2.5000000000000004
R_1_11_13_3 Node1_11_13 Node2_11_13 10240.000000000002
R_1_11_14_1 Node1_11_14 Node1_11_15 2.5000000000000004
R_1_11_14_2 Node1_11_14 Node1_12_14 2.5000000000000004
R_1_11_14_3 Node1_11_14 Node2_11_14 10240.000000000002
R_1_11_15_1 Node1_11_15 Node1_11_16 2.5000000000000004
R_1_11_15_2 Node1_11_15 Node1_12_15 2.5000000000000004
R_1_11_15_3 Node1_11_15 Node2_11_15 10240.000000000002
R_1_11_16_1 Node1_11_16 Node1_11_17 2.5000000000000004
R_1_11_16_2 Node1_11_16 Node1_12_16 2.5000000000000004
R_1_11_16_3 Node1_11_16 Node2_11_16 10240.000000000002
R_1_11_17_1 Node1_11_17 Node1_11_18 2.5000000000000004
R_1_11_17_2 Node1_11_17 Node1_12_17 2.5000000000000004
R_1_11_17_3 Node1_11_17 Node2_11_17 10240.000000000002
R_1_11_18_1 Node1_11_18 Node1_11_19 2.5000000000000004
R_1_11_18_2 Node1_11_18 Node1_12_18 2.5000000000000004
R_1_11_18_3 Node1_11_18 Node2_11_18 10240.000000000002
R_1_11_19_1 Node1_11_19 Node1_11_20 2.5000000000000004
R_1_11_19_2 Node1_11_19 Node1_12_19 2.5000000000000004
R_1_11_19_3 Node1_11_19 Node2_11_19 10240.000000000002
R_1_11_20_1 Node1_11_20 Node1_11_21 2.5000000000000004
R_1_11_20_2 Node1_11_20 Node1_12_20 2.5000000000000004
R_1_11_20_3 Node1_11_20 Node2_11_20 10240.000000000002
R_1_11_21_1 Node1_11_21 Node1_11_22 2.5000000000000004
R_1_11_21_2 Node1_11_21 Node1_12_21 2.5000000000000004
R_1_11_21_3 Node1_11_21 Node2_11_21 10240.000000000002
R_1_11_22_1 Node1_11_22 Node1_11_23 2.5000000000000004
R_1_11_22_2 Node1_11_22 Node1_12_22 2.5000000000000004
R_1_11_22_3 Node1_11_22 Node2_11_22 10240.000000000002
R_1_11_23_1 Node1_11_23 Node1_11_24 2.5000000000000004
R_1_11_23_2 Node1_11_23 Node1_12_23 2.5000000000000004
R_1_11_23_3 Node1_11_23 Node2_11_23 10240.000000000002
R_1_11_24_1 Node1_11_24 Node1_11_25 2.5000000000000004
R_1_11_24_2 Node1_11_24 Node1_12_24 2.5000000000000004
R_1_11_24_3 Node1_11_24 Node2_11_24 10240.000000000002
R_1_11_25_1 Node1_11_25 Node1_11_26 2.5000000000000004
R_1_11_25_2 Node1_11_25 Node1_12_25 2.5000000000000004
R_1_11_25_3 Node1_11_25 Node2_11_25 10240.000000000002
R_1_11_26_1 Node1_11_26 Node1_11_27 2.5000000000000004
R_1_11_26_2 Node1_11_26 Node1_12_26 2.5000000000000004
R_1_11_26_3 Node1_11_26 Node2_11_26 10240.000000000002
R_1_11_27_1 Node1_11_27 Node1_11_28 2.5000000000000004
R_1_11_27_2 Node1_11_27 Node1_12_27 2.5000000000000004
R_1_11_27_3 Node1_11_27 Node2_11_27 10240.000000000002
R_1_11_28_1 Node1_11_28 Node1_11_29 2.5000000000000004
R_1_11_28_2 Node1_11_28 Node1_12_28 2.5000000000000004
R_1_11_28_3 Node1_11_28 Node2_11_28 10240.000000000002
R_1_11_29_1 Node1_11_29 Node1_11_30 2.5000000000000004
R_1_11_29_2 Node1_11_29 Node1_12_29 2.5000000000000004
R_1_11_29_3 Node1_11_29 Node2_11_29 10240.000000000002
R_1_11_30_1 Node1_11_30 Node1_11_31 2.5000000000000004
R_1_11_30_2 Node1_11_30 Node1_12_30 2.5000000000000004
R_1_11_30_3 Node1_11_30 Node2_11_30 10240.000000000002
Rsp_1_11_31_1 Node1_11_31 Node_sp_right 71.54069767441861
R_1_11_31_2 Node1_11_31 Node1_12_31 2.5000000000000004
R_1_11_31_3 Node1_11_31 Node2_11_31 10240.000000000002
R_1_12_0_1 Node1_12_0 Node1_12_1 2.5000000000000004
Rsp_1_12_0_1 Node1_12_0 Node_sp_left 71.54069767441861
R_1_12_0_2 Node1_12_0 Node1_13_0 2.5000000000000004
R_1_12_0_3 Node1_12_0 Node2_12_0 10240.000000000002
R_1_12_1_1 Node1_12_1 Node1_12_2 2.5000000000000004
R_1_12_1_2 Node1_12_1 Node1_13_1 2.5000000000000004
R_1_12_1_3 Node1_12_1 Node2_12_1 10240.000000000002
R_1_12_2_1 Node1_12_2 Node1_12_3 2.5000000000000004
R_1_12_2_2 Node1_12_2 Node1_13_2 2.5000000000000004
R_1_12_2_3 Node1_12_2 Node2_12_2 10240.000000000002
R_1_12_3_1 Node1_12_3 Node1_12_4 2.5000000000000004
R_1_12_3_2 Node1_12_3 Node1_13_3 2.5000000000000004
R_1_12_3_3 Node1_12_3 Node2_12_3 10240.000000000002
R_1_12_4_1 Node1_12_4 Node1_12_5 2.5000000000000004
R_1_12_4_2 Node1_12_4 Node1_13_4 2.5000000000000004
R_1_12_4_3 Node1_12_4 Node2_12_4 10240.000000000002
R_1_12_5_1 Node1_12_5 Node1_12_6 2.5000000000000004
R_1_12_5_2 Node1_12_5 Node1_13_5 2.5000000000000004
R_1_12_5_3 Node1_12_5 Node2_12_5 10240.000000000002
R_1_12_6_1 Node1_12_6 Node1_12_7 2.5000000000000004
R_1_12_6_2 Node1_12_6 Node1_13_6 2.5000000000000004
R_1_12_6_3 Node1_12_6 Node2_12_6 10240.000000000002
R_1_12_7_1 Node1_12_7 Node1_12_8 2.5000000000000004
R_1_12_7_2 Node1_12_7 Node1_13_7 2.5000000000000004
R_1_12_7_3 Node1_12_7 Node2_12_7 10240.000000000002
R_1_12_8_1 Node1_12_8 Node1_12_9 2.5000000000000004
R_1_12_8_2 Node1_12_8 Node1_13_8 2.5000000000000004
R_1_12_8_3 Node1_12_8 Node2_12_8 10240.000000000002
R_1_12_9_1 Node1_12_9 Node1_12_10 2.5000000000000004
R_1_12_9_2 Node1_12_9 Node1_13_9 2.5000000000000004
R_1_12_9_3 Node1_12_9 Node2_12_9 10240.000000000002
R_1_12_10_1 Node1_12_10 Node1_12_11 2.5000000000000004
R_1_12_10_2 Node1_12_10 Node1_13_10 2.5000000000000004
R_1_12_10_3 Node1_12_10 Node2_12_10 10240.000000000002
R_1_12_11_1 Node1_12_11 Node1_12_12 2.5000000000000004
R_1_12_11_2 Node1_12_11 Node1_13_11 2.5000000000000004
R_1_12_11_3 Node1_12_11 Node2_12_11 10240.000000000002
R_1_12_12_1 Node1_12_12 Node1_12_13 2.5000000000000004
R_1_12_12_2 Node1_12_12 Node1_13_12 2.5000000000000004
R_1_12_12_3 Node1_12_12 Node2_12_12 10240.000000000002
R_1_12_13_1 Node1_12_13 Node1_12_14 2.5000000000000004
R_1_12_13_2 Node1_12_13 Node1_13_13 2.5000000000000004
R_1_12_13_3 Node1_12_13 Node2_12_13 10240.000000000002
R_1_12_14_1 Node1_12_14 Node1_12_15 2.5000000000000004
R_1_12_14_2 Node1_12_14 Node1_13_14 2.5000000000000004
R_1_12_14_3 Node1_12_14 Node2_12_14 10240.000000000002
R_1_12_15_1 Node1_12_15 Node1_12_16 2.5000000000000004
R_1_12_15_2 Node1_12_15 Node1_13_15 2.5000000000000004
R_1_12_15_3 Node1_12_15 Node2_12_15 10240.000000000002
R_1_12_16_1 Node1_12_16 Node1_12_17 2.5000000000000004
R_1_12_16_2 Node1_12_16 Node1_13_16 2.5000000000000004
R_1_12_16_3 Node1_12_16 Node2_12_16 10240.000000000002
R_1_12_17_1 Node1_12_17 Node1_12_18 2.5000000000000004
R_1_12_17_2 Node1_12_17 Node1_13_17 2.5000000000000004
R_1_12_17_3 Node1_12_17 Node2_12_17 10240.000000000002
R_1_12_18_1 Node1_12_18 Node1_12_19 2.5000000000000004
R_1_12_18_2 Node1_12_18 Node1_13_18 2.5000000000000004
R_1_12_18_3 Node1_12_18 Node2_12_18 10240.000000000002
R_1_12_19_1 Node1_12_19 Node1_12_20 2.5000000000000004
R_1_12_19_2 Node1_12_19 Node1_13_19 2.5000000000000004
R_1_12_19_3 Node1_12_19 Node2_12_19 10240.000000000002
R_1_12_20_1 Node1_12_20 Node1_12_21 2.5000000000000004
R_1_12_20_2 Node1_12_20 Node1_13_20 2.5000000000000004
R_1_12_20_3 Node1_12_20 Node2_12_20 10240.000000000002
R_1_12_21_1 Node1_12_21 Node1_12_22 2.5000000000000004
R_1_12_21_2 Node1_12_21 Node1_13_21 2.5000000000000004
R_1_12_21_3 Node1_12_21 Node2_12_21 10240.000000000002
R_1_12_22_1 Node1_12_22 Node1_12_23 2.5000000000000004
R_1_12_22_2 Node1_12_22 Node1_13_22 2.5000000000000004
R_1_12_22_3 Node1_12_22 Node2_12_22 10240.000000000002
R_1_12_23_1 Node1_12_23 Node1_12_24 2.5000000000000004
R_1_12_23_2 Node1_12_23 Node1_13_23 2.5000000000000004
R_1_12_23_3 Node1_12_23 Node2_12_23 10240.000000000002
R_1_12_24_1 Node1_12_24 Node1_12_25 2.5000000000000004
R_1_12_24_2 Node1_12_24 Node1_13_24 2.5000000000000004
R_1_12_24_3 Node1_12_24 Node2_12_24 10240.000000000002
R_1_12_25_1 Node1_12_25 Node1_12_26 2.5000000000000004
R_1_12_25_2 Node1_12_25 Node1_13_25 2.5000000000000004
R_1_12_25_3 Node1_12_25 Node2_12_25 10240.000000000002
R_1_12_26_1 Node1_12_26 Node1_12_27 2.5000000000000004
R_1_12_26_2 Node1_12_26 Node1_13_26 2.5000000000000004
R_1_12_26_3 Node1_12_26 Node2_12_26 10240.000000000002
R_1_12_27_1 Node1_12_27 Node1_12_28 2.5000000000000004
R_1_12_27_2 Node1_12_27 Node1_13_27 2.5000000000000004
R_1_12_27_3 Node1_12_27 Node2_12_27 10240.000000000002
R_1_12_28_1 Node1_12_28 Node1_12_29 2.5000000000000004
R_1_12_28_2 Node1_12_28 Node1_13_28 2.5000000000000004
R_1_12_28_3 Node1_12_28 Node2_12_28 10240.000000000002
R_1_12_29_1 Node1_12_29 Node1_12_30 2.5000000000000004
R_1_12_29_2 Node1_12_29 Node1_13_29 2.5000000000000004
R_1_12_29_3 Node1_12_29 Node2_12_29 10240.000000000002
R_1_12_30_1 Node1_12_30 Node1_12_31 2.5000000000000004
R_1_12_30_2 Node1_12_30 Node1_13_30 2.5000000000000004
R_1_12_30_3 Node1_12_30 Node2_12_30 10240.000000000002
Rsp_1_12_31_1 Node1_12_31 Node_sp_right 71.54069767441861
R_1_12_31_2 Node1_12_31 Node1_13_31 2.5000000000000004
R_1_12_31_3 Node1_12_31 Node2_12_31 10240.000000000002
R_1_13_0_1 Node1_13_0 Node1_13_1 2.5000000000000004
Rsp_1_13_0_1 Node1_13_0 Node_sp_left 71.54069767441861
R_1_13_0_2 Node1_13_0 Node1_14_0 2.5000000000000004
R_1_13_0_3 Node1_13_0 Node2_13_0 10240.000000000002
R_1_13_1_1 Node1_13_1 Node1_13_2 2.5000000000000004
R_1_13_1_2 Node1_13_1 Node1_14_1 2.5000000000000004
R_1_13_1_3 Node1_13_1 Node2_13_1 10240.000000000002
R_1_13_2_1 Node1_13_2 Node1_13_3 2.5000000000000004
R_1_13_2_2 Node1_13_2 Node1_14_2 2.5000000000000004
R_1_13_2_3 Node1_13_2 Node2_13_2 10240.000000000002
R_1_13_3_1 Node1_13_3 Node1_13_4 2.5000000000000004
R_1_13_3_2 Node1_13_3 Node1_14_3 2.5000000000000004
R_1_13_3_3 Node1_13_3 Node2_13_3 10240.000000000002
R_1_13_4_1 Node1_13_4 Node1_13_5 2.5000000000000004
R_1_13_4_2 Node1_13_4 Node1_14_4 2.5000000000000004
R_1_13_4_3 Node1_13_4 Node2_13_4 10240.000000000002
R_1_13_5_1 Node1_13_5 Node1_13_6 2.5000000000000004
R_1_13_5_2 Node1_13_5 Node1_14_5 2.5000000000000004
R_1_13_5_3 Node1_13_5 Node2_13_5 10240.000000000002
R_1_13_6_1 Node1_13_6 Node1_13_7 2.5000000000000004
R_1_13_6_2 Node1_13_6 Node1_14_6 2.5000000000000004
R_1_13_6_3 Node1_13_6 Node2_13_6 10240.000000000002
R_1_13_7_1 Node1_13_7 Node1_13_8 2.5000000000000004
R_1_13_7_2 Node1_13_7 Node1_14_7 2.5000000000000004
R_1_13_7_3 Node1_13_7 Node2_13_7 10240.000000000002
R_1_13_8_1 Node1_13_8 Node1_13_9 2.5000000000000004
R_1_13_8_2 Node1_13_8 Node1_14_8 2.5000000000000004
R_1_13_8_3 Node1_13_8 Node2_13_8 10240.000000000002
R_1_13_9_1 Node1_13_9 Node1_13_10 2.5000000000000004
R_1_13_9_2 Node1_13_9 Node1_14_9 2.5000000000000004
R_1_13_9_3 Node1_13_9 Node2_13_9 10240.000000000002
R_1_13_10_1 Node1_13_10 Node1_13_11 2.5000000000000004
R_1_13_10_2 Node1_13_10 Node1_14_10 2.5000000000000004
R_1_13_10_3 Node1_13_10 Node2_13_10 10240.000000000002
R_1_13_11_1 Node1_13_11 Node1_13_12 2.5000000000000004
R_1_13_11_2 Node1_13_11 Node1_14_11 2.5000000000000004
R_1_13_11_3 Node1_13_11 Node2_13_11 10240.000000000002
R_1_13_12_1 Node1_13_12 Node1_13_13 2.5000000000000004
R_1_13_12_2 Node1_13_12 Node1_14_12 2.5000000000000004
R_1_13_12_3 Node1_13_12 Node2_13_12 10240.000000000002
R_1_13_13_1 Node1_13_13 Node1_13_14 2.5000000000000004
R_1_13_13_2 Node1_13_13 Node1_14_13 2.5000000000000004
R_1_13_13_3 Node1_13_13 Node2_13_13 10240.000000000002
R_1_13_14_1 Node1_13_14 Node1_13_15 2.5000000000000004
R_1_13_14_2 Node1_13_14 Node1_14_14 2.5000000000000004
R_1_13_14_3 Node1_13_14 Node2_13_14 10240.000000000002
R_1_13_15_1 Node1_13_15 Node1_13_16 2.5000000000000004
R_1_13_15_2 Node1_13_15 Node1_14_15 2.5000000000000004
R_1_13_15_3 Node1_13_15 Node2_13_15 10240.000000000002
R_1_13_16_1 Node1_13_16 Node1_13_17 2.5000000000000004
R_1_13_16_2 Node1_13_16 Node1_14_16 2.5000000000000004
R_1_13_16_3 Node1_13_16 Node2_13_16 10240.000000000002
R_1_13_17_1 Node1_13_17 Node1_13_18 2.5000000000000004
R_1_13_17_2 Node1_13_17 Node1_14_17 2.5000000000000004
R_1_13_17_3 Node1_13_17 Node2_13_17 10240.000000000002
R_1_13_18_1 Node1_13_18 Node1_13_19 2.5000000000000004
R_1_13_18_2 Node1_13_18 Node1_14_18 2.5000000000000004
R_1_13_18_3 Node1_13_18 Node2_13_18 10240.000000000002
R_1_13_19_1 Node1_13_19 Node1_13_20 2.5000000000000004
R_1_13_19_2 Node1_13_19 Node1_14_19 2.5000000000000004
R_1_13_19_3 Node1_13_19 Node2_13_19 10240.000000000002
R_1_13_20_1 Node1_13_20 Node1_13_21 2.5000000000000004
R_1_13_20_2 Node1_13_20 Node1_14_20 2.5000000000000004
R_1_13_20_3 Node1_13_20 Node2_13_20 10240.000000000002
R_1_13_21_1 Node1_13_21 Node1_13_22 2.5000000000000004
R_1_13_21_2 Node1_13_21 Node1_14_21 2.5000000000000004
R_1_13_21_3 Node1_13_21 Node2_13_21 10240.000000000002
R_1_13_22_1 Node1_13_22 Node1_13_23 2.5000000000000004
R_1_13_22_2 Node1_13_22 Node1_14_22 2.5000000000000004
R_1_13_22_3 Node1_13_22 Node2_13_22 10240.000000000002
R_1_13_23_1 Node1_13_23 Node1_13_24 2.5000000000000004
R_1_13_23_2 Node1_13_23 Node1_14_23 2.5000000000000004
R_1_13_23_3 Node1_13_23 Node2_13_23 10240.000000000002
R_1_13_24_1 Node1_13_24 Node1_13_25 2.5000000000000004
R_1_13_24_2 Node1_13_24 Node1_14_24 2.5000000000000004
R_1_13_24_3 Node1_13_24 Node2_13_24 10240.000000000002
R_1_13_25_1 Node1_13_25 Node1_13_26 2.5000000000000004
R_1_13_25_2 Node1_13_25 Node1_14_25 2.5000000000000004
R_1_13_25_3 Node1_13_25 Node2_13_25 10240.000000000002
R_1_13_26_1 Node1_13_26 Node1_13_27 2.5000000000000004
R_1_13_26_2 Node1_13_26 Node1_14_26 2.5000000000000004
R_1_13_26_3 Node1_13_26 Node2_13_26 10240.000000000002
R_1_13_27_1 Node1_13_27 Node1_13_28 2.5000000000000004
R_1_13_27_2 Node1_13_27 Node1_14_27 2.5000000000000004
R_1_13_27_3 Node1_13_27 Node2_13_27 10240.000000000002
R_1_13_28_1 Node1_13_28 Node1_13_29 2.5000000000000004
R_1_13_28_2 Node1_13_28 Node1_14_28 2.5000000000000004
R_1_13_28_3 Node1_13_28 Node2_13_28 10240.000000000002
R_1_13_29_1 Node1_13_29 Node1_13_30 2.5000000000000004
R_1_13_29_2 Node1_13_29 Node1_14_29 2.5000000000000004
R_1_13_29_3 Node1_13_29 Node2_13_29 10240.000000000002
R_1_13_30_1 Node1_13_30 Node1_13_31 2.5000000000000004
R_1_13_30_2 Node1_13_30 Node1_14_30 2.5000000000000004
R_1_13_30_3 Node1_13_30 Node2_13_30 10240.000000000002
Rsp_1_13_31_1 Node1_13_31 Node_sp_right 71.54069767441861
R_1_13_31_2 Node1_13_31 Node1_14_31 2.5000000000000004
R_1_13_31_3 Node1_13_31 Node2_13_31 10240.000000000002
R_1_14_0_1 Node1_14_0 Node1_14_1 2.5000000000000004
Rsp_1_14_0_1 Node1_14_0 Node_sp_left 71.54069767441861
R_1_14_0_2 Node1_14_0 Node1_15_0 2.5000000000000004
R_1_14_0_3 Node1_14_0 Node2_14_0 10240.000000000002
R_1_14_1_1 Node1_14_1 Node1_14_2 2.5000000000000004
R_1_14_1_2 Node1_14_1 Node1_15_1 2.5000000000000004
R_1_14_1_3 Node1_14_1 Node2_14_1 10240.000000000002
R_1_14_2_1 Node1_14_2 Node1_14_3 2.5000000000000004
R_1_14_2_2 Node1_14_2 Node1_15_2 2.5000000000000004
R_1_14_2_3 Node1_14_2 Node2_14_2 10240.000000000002
R_1_14_3_1 Node1_14_3 Node1_14_4 2.5000000000000004
R_1_14_3_2 Node1_14_3 Node1_15_3 2.5000000000000004
R_1_14_3_3 Node1_14_3 Node2_14_3 10240.000000000002
R_1_14_4_1 Node1_14_4 Node1_14_5 2.5000000000000004
R_1_14_4_2 Node1_14_4 Node1_15_4 2.5000000000000004
R_1_14_4_3 Node1_14_4 Node2_14_4 10240.000000000002
R_1_14_5_1 Node1_14_5 Node1_14_6 2.5000000000000004
R_1_14_5_2 Node1_14_5 Node1_15_5 2.5000000000000004
R_1_14_5_3 Node1_14_5 Node2_14_5 10240.000000000002
R_1_14_6_1 Node1_14_6 Node1_14_7 2.5000000000000004
R_1_14_6_2 Node1_14_6 Node1_15_6 2.5000000000000004
R_1_14_6_3 Node1_14_6 Node2_14_6 10240.000000000002
R_1_14_7_1 Node1_14_7 Node1_14_8 2.5000000000000004
R_1_14_7_2 Node1_14_7 Node1_15_7 2.5000000000000004
R_1_14_7_3 Node1_14_7 Node2_14_7 10240.000000000002
R_1_14_8_1 Node1_14_8 Node1_14_9 2.5000000000000004
R_1_14_8_2 Node1_14_8 Node1_15_8 2.5000000000000004
R_1_14_8_3 Node1_14_8 Node2_14_8 10240.000000000002
R_1_14_9_1 Node1_14_9 Node1_14_10 2.5000000000000004
R_1_14_9_2 Node1_14_9 Node1_15_9 2.5000000000000004
R_1_14_9_3 Node1_14_9 Node2_14_9 10240.000000000002
R_1_14_10_1 Node1_14_10 Node1_14_11 2.5000000000000004
R_1_14_10_2 Node1_14_10 Node1_15_10 2.5000000000000004
R_1_14_10_3 Node1_14_10 Node2_14_10 10240.000000000002
R_1_14_11_1 Node1_14_11 Node1_14_12 2.5000000000000004
R_1_14_11_2 Node1_14_11 Node1_15_11 2.5000000000000004
R_1_14_11_3 Node1_14_11 Node2_14_11 10240.000000000002
R_1_14_12_1 Node1_14_12 Node1_14_13 2.5000000000000004
R_1_14_12_2 Node1_14_12 Node1_15_12 2.5000000000000004
R_1_14_12_3 Node1_14_12 Node2_14_12 10240.000000000002
R_1_14_13_1 Node1_14_13 Node1_14_14 2.5000000000000004
R_1_14_13_2 Node1_14_13 Node1_15_13 2.5000000000000004
R_1_14_13_3 Node1_14_13 Node2_14_13 10240.000000000002
R_1_14_14_1 Node1_14_14 Node1_14_15 2.5000000000000004
R_1_14_14_2 Node1_14_14 Node1_15_14 2.5000000000000004
R_1_14_14_3 Node1_14_14 Node2_14_14 10240.000000000002
R_1_14_15_1 Node1_14_15 Node1_14_16 2.5000000000000004
R_1_14_15_2 Node1_14_15 Node1_15_15 2.5000000000000004
R_1_14_15_3 Node1_14_15 Node2_14_15 10240.000000000002
R_1_14_16_1 Node1_14_16 Node1_14_17 2.5000000000000004
R_1_14_16_2 Node1_14_16 Node1_15_16 2.5000000000000004
R_1_14_16_3 Node1_14_16 Node2_14_16 10240.000000000002
R_1_14_17_1 Node1_14_17 Node1_14_18 2.5000000000000004
R_1_14_17_2 Node1_14_17 Node1_15_17 2.5000000000000004
R_1_14_17_3 Node1_14_17 Node2_14_17 10240.000000000002
R_1_14_18_1 Node1_14_18 Node1_14_19 2.5000000000000004
R_1_14_18_2 Node1_14_18 Node1_15_18 2.5000000000000004
R_1_14_18_3 Node1_14_18 Node2_14_18 10240.000000000002
R_1_14_19_1 Node1_14_19 Node1_14_20 2.5000000000000004
R_1_14_19_2 Node1_14_19 Node1_15_19 2.5000000000000004
R_1_14_19_3 Node1_14_19 Node2_14_19 10240.000000000002
R_1_14_20_1 Node1_14_20 Node1_14_21 2.5000000000000004
R_1_14_20_2 Node1_14_20 Node1_15_20 2.5000000000000004
R_1_14_20_3 Node1_14_20 Node2_14_20 10240.000000000002
R_1_14_21_1 Node1_14_21 Node1_14_22 2.5000000000000004
R_1_14_21_2 Node1_14_21 Node1_15_21 2.5000000000000004
R_1_14_21_3 Node1_14_21 Node2_14_21 10240.000000000002
R_1_14_22_1 Node1_14_22 Node1_14_23 2.5000000000000004
R_1_14_22_2 Node1_14_22 Node1_15_22 2.5000000000000004
R_1_14_22_3 Node1_14_22 Node2_14_22 10240.000000000002
R_1_14_23_1 Node1_14_23 Node1_14_24 2.5000000000000004
R_1_14_23_2 Node1_14_23 Node1_15_23 2.5000000000000004
R_1_14_23_3 Node1_14_23 Node2_14_23 10240.000000000002
R_1_14_24_1 Node1_14_24 Node1_14_25 2.5000000000000004
R_1_14_24_2 Node1_14_24 Node1_15_24 2.5000000000000004
R_1_14_24_3 Node1_14_24 Node2_14_24 10240.000000000002
R_1_14_25_1 Node1_14_25 Node1_14_26 2.5000000000000004
R_1_14_25_2 Node1_14_25 Node1_15_25 2.5000000000000004
R_1_14_25_3 Node1_14_25 Node2_14_25 10240.000000000002
R_1_14_26_1 Node1_14_26 Node1_14_27 2.5000000000000004
R_1_14_26_2 Node1_14_26 Node1_15_26 2.5000000000000004
R_1_14_26_3 Node1_14_26 Node2_14_26 10240.000000000002
R_1_14_27_1 Node1_14_27 Node1_14_28 2.5000000000000004
R_1_14_27_2 Node1_14_27 Node1_15_27 2.5000000000000004
R_1_14_27_3 Node1_14_27 Node2_14_27 10240.000000000002
R_1_14_28_1 Node1_14_28 Node1_14_29 2.5000000000000004
R_1_14_28_2 Node1_14_28 Node1_15_28 2.5000000000000004
R_1_14_28_3 Node1_14_28 Node2_14_28 10240.000000000002
R_1_14_29_1 Node1_14_29 Node1_14_30 2.5000000000000004
R_1_14_29_2 Node1_14_29 Node1_15_29 2.5000000000000004
R_1_14_29_3 Node1_14_29 Node2_14_29 10240.000000000002
R_1_14_30_1 Node1_14_30 Node1_14_31 2.5000000000000004
R_1_14_30_2 Node1_14_30 Node1_15_30 2.5000000000000004
R_1_14_30_3 Node1_14_30 Node2_14_30 10240.000000000002
Rsp_1_14_31_1 Node1_14_31 Node_sp_right 71.54069767441861
R_1_14_31_2 Node1_14_31 Node1_15_31 2.5000000000000004
R_1_14_31_3 Node1_14_31 Node2_14_31 10240.000000000002
R_1_15_0_1 Node1_15_0 Node1_15_1 2.5000000000000004
Rsp_1_15_0_1 Node1_15_0 Node_sp_left 71.54069767441861
R_1_15_0_2 Node1_15_0 Node1_16_0 2.5000000000000004
R_1_15_0_3 Node1_15_0 Node2_15_0 10240.000000000002
R_1_15_1_1 Node1_15_1 Node1_15_2 2.5000000000000004
R_1_15_1_2 Node1_15_1 Node1_16_1 2.5000000000000004
R_1_15_1_3 Node1_15_1 Node2_15_1 10240.000000000002
R_1_15_2_1 Node1_15_2 Node1_15_3 2.5000000000000004
R_1_15_2_2 Node1_15_2 Node1_16_2 2.5000000000000004
R_1_15_2_3 Node1_15_2 Node2_15_2 10240.000000000002
R_1_15_3_1 Node1_15_3 Node1_15_4 2.5000000000000004
R_1_15_3_2 Node1_15_3 Node1_16_3 2.5000000000000004
R_1_15_3_3 Node1_15_3 Node2_15_3 10240.000000000002
R_1_15_4_1 Node1_15_4 Node1_15_5 2.5000000000000004
R_1_15_4_2 Node1_15_4 Node1_16_4 2.5000000000000004
R_1_15_4_3 Node1_15_4 Node2_15_4 10240.000000000002
R_1_15_5_1 Node1_15_5 Node1_15_6 2.5000000000000004
R_1_15_5_2 Node1_15_5 Node1_16_5 2.5000000000000004
R_1_15_5_3 Node1_15_5 Node2_15_5 10240.000000000002
R_1_15_6_1 Node1_15_6 Node1_15_7 2.5000000000000004
R_1_15_6_2 Node1_15_6 Node1_16_6 2.5000000000000004
R_1_15_6_3 Node1_15_6 Node2_15_6 10240.000000000002
R_1_15_7_1 Node1_15_7 Node1_15_8 2.5000000000000004
R_1_15_7_2 Node1_15_7 Node1_16_7 2.5000000000000004
R_1_15_7_3 Node1_15_7 Node2_15_7 10240.000000000002
R_1_15_8_1 Node1_15_8 Node1_15_9 2.5000000000000004
R_1_15_8_2 Node1_15_8 Node1_16_8 2.5000000000000004
R_1_15_8_3 Node1_15_8 Node2_15_8 10240.000000000002
R_1_15_9_1 Node1_15_9 Node1_15_10 2.5000000000000004
R_1_15_9_2 Node1_15_9 Node1_16_9 2.5000000000000004
R_1_15_9_3 Node1_15_9 Node2_15_9 10240.000000000002
R_1_15_10_1 Node1_15_10 Node1_15_11 2.5000000000000004
R_1_15_10_2 Node1_15_10 Node1_16_10 2.5000000000000004
R_1_15_10_3 Node1_15_10 Node2_15_10 10240.000000000002
R_1_15_11_1 Node1_15_11 Node1_15_12 2.5000000000000004
R_1_15_11_2 Node1_15_11 Node1_16_11 2.5000000000000004
R_1_15_11_3 Node1_15_11 Node2_15_11 10240.000000000002
R_1_15_12_1 Node1_15_12 Node1_15_13 2.5000000000000004
R_1_15_12_2 Node1_15_12 Node1_16_12 2.5000000000000004
R_1_15_12_3 Node1_15_12 Node2_15_12 10240.000000000002
R_1_15_13_1 Node1_15_13 Node1_15_14 2.5000000000000004
R_1_15_13_2 Node1_15_13 Node1_16_13 2.5000000000000004
R_1_15_13_3 Node1_15_13 Node2_15_13 10240.000000000002
R_1_15_14_1 Node1_15_14 Node1_15_15 2.5000000000000004
R_1_15_14_2 Node1_15_14 Node1_16_14 2.5000000000000004
R_1_15_14_3 Node1_15_14 Node2_15_14 10240.000000000002
R_1_15_15_1 Node1_15_15 Node1_15_16 2.5000000000000004
R_1_15_15_2 Node1_15_15 Node1_16_15 2.5000000000000004
R_1_15_15_3 Node1_15_15 Node2_15_15 10240.000000000002
R_1_15_16_1 Node1_15_16 Node1_15_17 2.5000000000000004
R_1_15_16_2 Node1_15_16 Node1_16_16 2.5000000000000004
R_1_15_16_3 Node1_15_16 Node2_15_16 10240.000000000002
R_1_15_17_1 Node1_15_17 Node1_15_18 2.5000000000000004
R_1_15_17_2 Node1_15_17 Node1_16_17 2.5000000000000004
R_1_15_17_3 Node1_15_17 Node2_15_17 10240.000000000002
R_1_15_18_1 Node1_15_18 Node1_15_19 2.5000000000000004
R_1_15_18_2 Node1_15_18 Node1_16_18 2.5000000000000004
R_1_15_18_3 Node1_15_18 Node2_15_18 10240.000000000002
R_1_15_19_1 Node1_15_19 Node1_15_20 2.5000000000000004
R_1_15_19_2 Node1_15_19 Node1_16_19 2.5000000000000004
R_1_15_19_3 Node1_15_19 Node2_15_19 10240.000000000002
R_1_15_20_1 Node1_15_20 Node1_15_21 2.5000000000000004
R_1_15_20_2 Node1_15_20 Node1_16_20 2.5000000000000004
R_1_15_20_3 Node1_15_20 Node2_15_20 10240.000000000002
R_1_15_21_1 Node1_15_21 Node1_15_22 2.5000000000000004
R_1_15_21_2 Node1_15_21 Node1_16_21 2.5000000000000004
R_1_15_21_3 Node1_15_21 Node2_15_21 10240.000000000002
R_1_15_22_1 Node1_15_22 Node1_15_23 2.5000000000000004
R_1_15_22_2 Node1_15_22 Node1_16_22 2.5000000000000004
R_1_15_22_3 Node1_15_22 Node2_15_22 10240.000000000002
R_1_15_23_1 Node1_15_23 Node1_15_24 2.5000000000000004
R_1_15_23_2 Node1_15_23 Node1_16_23 2.5000000000000004
R_1_15_23_3 Node1_15_23 Node2_15_23 10240.000000000002
R_1_15_24_1 Node1_15_24 Node1_15_25 2.5000000000000004
R_1_15_24_2 Node1_15_24 Node1_16_24 2.5000000000000004
R_1_15_24_3 Node1_15_24 Node2_15_24 10240.000000000002
R_1_15_25_1 Node1_15_25 Node1_15_26 2.5000000000000004
R_1_15_25_2 Node1_15_25 Node1_16_25 2.5000000000000004
R_1_15_25_3 Node1_15_25 Node2_15_25 10240.000000000002
R_1_15_26_1 Node1_15_26 Node1_15_27 2.5000000000000004
R_1_15_26_2 Node1_15_26 Node1_16_26 2.5000000000000004
R_1_15_26_3 Node1_15_26 Node2_15_26 10240.000000000002
R_1_15_27_1 Node1_15_27 Node1_15_28 2.5000000000000004
R_1_15_27_2 Node1_15_27 Node1_16_27 2.5000000000000004
R_1_15_27_3 Node1_15_27 Node2_15_27 10240.000000000002
R_1_15_28_1 Node1_15_28 Node1_15_29 2.5000000000000004
R_1_15_28_2 Node1_15_28 Node1_16_28 2.5000000000000004
R_1_15_28_3 Node1_15_28 Node2_15_28 10240.000000000002
R_1_15_29_1 Node1_15_29 Node1_15_30 2.5000000000000004
R_1_15_29_2 Node1_15_29 Node1_16_29 2.5000000000000004
R_1_15_29_3 Node1_15_29 Node2_15_29 10240.000000000002
R_1_15_30_1 Node1_15_30 Node1_15_31 2.5000000000000004
R_1_15_30_2 Node1_15_30 Node1_16_30 2.5000000000000004
R_1_15_30_3 Node1_15_30 Node2_15_30 10240.000000000002
Rsp_1_15_31_1 Node1_15_31 Node_sp_right 71.54069767441861
R_1_15_31_2 Node1_15_31 Node1_16_31 2.5000000000000004
R_1_15_31_3 Node1_15_31 Node2_15_31 10240.000000000002
R_1_16_0_1 Node1_16_0 Node1_16_1 2.5000000000000004
Rsp_1_16_0_1 Node1_16_0 Node_sp_left 71.54069767441861
R_1_16_0_2 Node1_16_0 Node1_17_0 2.5000000000000004
R_1_16_0_3 Node1_16_0 Node2_16_0 10240.000000000002
R_1_16_1_1 Node1_16_1 Node1_16_2 2.5000000000000004
R_1_16_1_2 Node1_16_1 Node1_17_1 2.5000000000000004
R_1_16_1_3 Node1_16_1 Node2_16_1 10240.000000000002
R_1_16_2_1 Node1_16_2 Node1_16_3 2.5000000000000004
R_1_16_2_2 Node1_16_2 Node1_17_2 2.5000000000000004
R_1_16_2_3 Node1_16_2 Node2_16_2 10240.000000000002
R_1_16_3_1 Node1_16_3 Node1_16_4 2.5000000000000004
R_1_16_3_2 Node1_16_3 Node1_17_3 2.5000000000000004
R_1_16_3_3 Node1_16_3 Node2_16_3 10240.000000000002
R_1_16_4_1 Node1_16_4 Node1_16_5 2.5000000000000004
R_1_16_4_2 Node1_16_4 Node1_17_4 2.5000000000000004
R_1_16_4_3 Node1_16_4 Node2_16_4 10240.000000000002
R_1_16_5_1 Node1_16_5 Node1_16_6 2.5000000000000004
R_1_16_5_2 Node1_16_5 Node1_17_5 2.5000000000000004
R_1_16_5_3 Node1_16_5 Node2_16_5 10240.000000000002
R_1_16_6_1 Node1_16_6 Node1_16_7 2.5000000000000004
R_1_16_6_2 Node1_16_6 Node1_17_6 2.5000000000000004
R_1_16_6_3 Node1_16_6 Node2_16_6 10240.000000000002
R_1_16_7_1 Node1_16_7 Node1_16_8 2.5000000000000004
R_1_16_7_2 Node1_16_7 Node1_17_7 2.5000000000000004
R_1_16_7_3 Node1_16_7 Node2_16_7 10240.000000000002
R_1_16_8_1 Node1_16_8 Node1_16_9 2.5000000000000004
R_1_16_8_2 Node1_16_8 Node1_17_8 2.5000000000000004
R_1_16_8_3 Node1_16_8 Node2_16_8 10240.000000000002
R_1_16_9_1 Node1_16_9 Node1_16_10 2.5000000000000004
R_1_16_9_2 Node1_16_9 Node1_17_9 2.5000000000000004
R_1_16_9_3 Node1_16_9 Node2_16_9 10240.000000000002
R_1_16_10_1 Node1_16_10 Node1_16_11 2.5000000000000004
R_1_16_10_2 Node1_16_10 Node1_17_10 2.5000000000000004
R_1_16_10_3 Node1_16_10 Node2_16_10 10240.000000000002
R_1_16_11_1 Node1_16_11 Node1_16_12 2.5000000000000004
R_1_16_11_2 Node1_16_11 Node1_17_11 2.5000000000000004
R_1_16_11_3 Node1_16_11 Node2_16_11 10240.000000000002
R_1_16_12_1 Node1_16_12 Node1_16_13 2.5000000000000004
R_1_16_12_2 Node1_16_12 Node1_17_12 2.5000000000000004
R_1_16_12_3 Node1_16_12 Node2_16_12 10240.000000000002
R_1_16_13_1 Node1_16_13 Node1_16_14 2.5000000000000004
R_1_16_13_2 Node1_16_13 Node1_17_13 2.5000000000000004
R_1_16_13_3 Node1_16_13 Node2_16_13 10240.000000000002
R_1_16_14_1 Node1_16_14 Node1_16_15 2.5000000000000004
R_1_16_14_2 Node1_16_14 Node1_17_14 2.5000000000000004
R_1_16_14_3 Node1_16_14 Node2_16_14 10240.000000000002
R_1_16_15_1 Node1_16_15 Node1_16_16 2.5000000000000004
R_1_16_15_2 Node1_16_15 Node1_17_15 2.5000000000000004
R_1_16_15_3 Node1_16_15 Node2_16_15 10240.000000000002
R_1_16_16_1 Node1_16_16 Node1_16_17 2.5000000000000004
R_1_16_16_2 Node1_16_16 Node1_17_16 2.5000000000000004
R_1_16_16_3 Node1_16_16 Node2_16_16 10240.000000000002
R_1_16_17_1 Node1_16_17 Node1_16_18 2.5000000000000004
R_1_16_17_2 Node1_16_17 Node1_17_17 2.5000000000000004
R_1_16_17_3 Node1_16_17 Node2_16_17 10240.000000000002
R_1_16_18_1 Node1_16_18 Node1_16_19 2.5000000000000004
R_1_16_18_2 Node1_16_18 Node1_17_18 2.5000000000000004
R_1_16_18_3 Node1_16_18 Node2_16_18 10240.000000000002
R_1_16_19_1 Node1_16_19 Node1_16_20 2.5000000000000004
R_1_16_19_2 Node1_16_19 Node1_17_19 2.5000000000000004
R_1_16_19_3 Node1_16_19 Node2_16_19 10240.000000000002
R_1_16_20_1 Node1_16_20 Node1_16_21 2.5000000000000004
R_1_16_20_2 Node1_16_20 Node1_17_20 2.5000000000000004
R_1_16_20_3 Node1_16_20 Node2_16_20 10240.000000000002
R_1_16_21_1 Node1_16_21 Node1_16_22 2.5000000000000004
R_1_16_21_2 Node1_16_21 Node1_17_21 2.5000000000000004
R_1_16_21_3 Node1_16_21 Node2_16_21 10240.000000000002
R_1_16_22_1 Node1_16_22 Node1_16_23 2.5000000000000004
R_1_16_22_2 Node1_16_22 Node1_17_22 2.5000000000000004
R_1_16_22_3 Node1_16_22 Node2_16_22 10240.000000000002
R_1_16_23_1 Node1_16_23 Node1_16_24 2.5000000000000004
R_1_16_23_2 Node1_16_23 Node1_17_23 2.5000000000000004
R_1_16_23_3 Node1_16_23 Node2_16_23 10240.000000000002
R_1_16_24_1 Node1_16_24 Node1_16_25 2.5000000000000004
R_1_16_24_2 Node1_16_24 Node1_17_24 2.5000000000000004
R_1_16_24_3 Node1_16_24 Node2_16_24 10240.000000000002
R_1_16_25_1 Node1_16_25 Node1_16_26 2.5000000000000004
R_1_16_25_2 Node1_16_25 Node1_17_25 2.5000000000000004
R_1_16_25_3 Node1_16_25 Node2_16_25 10240.000000000002
R_1_16_26_1 Node1_16_26 Node1_16_27 2.5000000000000004
R_1_16_26_2 Node1_16_26 Node1_17_26 2.5000000000000004
R_1_16_26_3 Node1_16_26 Node2_16_26 10240.000000000002
R_1_16_27_1 Node1_16_27 Node1_16_28 2.5000000000000004
R_1_16_27_2 Node1_16_27 Node1_17_27 2.5000000000000004
R_1_16_27_3 Node1_16_27 Node2_16_27 10240.000000000002
R_1_16_28_1 Node1_16_28 Node1_16_29 2.5000000000000004
R_1_16_28_2 Node1_16_28 Node1_17_28 2.5000000000000004
R_1_16_28_3 Node1_16_28 Node2_16_28 10240.000000000002
R_1_16_29_1 Node1_16_29 Node1_16_30 2.5000000000000004
R_1_16_29_2 Node1_16_29 Node1_17_29 2.5000000000000004
R_1_16_29_3 Node1_16_29 Node2_16_29 10240.000000000002
R_1_16_30_1 Node1_16_30 Node1_16_31 2.5000000000000004
R_1_16_30_2 Node1_16_30 Node1_17_30 2.5000000000000004
R_1_16_30_3 Node1_16_30 Node2_16_30 10240.000000000002
Rsp_1_16_31_1 Node1_16_31 Node_sp_right 71.54069767441861
R_1_16_31_2 Node1_16_31 Node1_17_31 2.5000000000000004
R_1_16_31_3 Node1_16_31 Node2_16_31 10240.000000000002
R_1_17_0_1 Node1_17_0 Node1_17_1 2.5000000000000004
Rsp_1_17_0_1 Node1_17_0 Node_sp_left 71.54069767441861
R_1_17_0_2 Node1_17_0 Node1_18_0 2.5000000000000004
R_1_17_0_3 Node1_17_0 Node2_17_0 10240.000000000002
R_1_17_1_1 Node1_17_1 Node1_17_2 2.5000000000000004
R_1_17_1_2 Node1_17_1 Node1_18_1 2.5000000000000004
R_1_17_1_3 Node1_17_1 Node2_17_1 10240.000000000002
R_1_17_2_1 Node1_17_2 Node1_17_3 2.5000000000000004
R_1_17_2_2 Node1_17_2 Node1_18_2 2.5000000000000004
R_1_17_2_3 Node1_17_2 Node2_17_2 10240.000000000002
R_1_17_3_1 Node1_17_3 Node1_17_4 2.5000000000000004
R_1_17_3_2 Node1_17_3 Node1_18_3 2.5000000000000004
R_1_17_3_3 Node1_17_3 Node2_17_3 10240.000000000002
R_1_17_4_1 Node1_17_4 Node1_17_5 2.5000000000000004
R_1_17_4_2 Node1_17_4 Node1_18_4 2.5000000000000004
R_1_17_4_3 Node1_17_4 Node2_17_4 10240.000000000002
R_1_17_5_1 Node1_17_5 Node1_17_6 2.5000000000000004
R_1_17_5_2 Node1_17_5 Node1_18_5 2.5000000000000004
R_1_17_5_3 Node1_17_5 Node2_17_5 10240.000000000002
R_1_17_6_1 Node1_17_6 Node1_17_7 2.5000000000000004
R_1_17_6_2 Node1_17_6 Node1_18_6 2.5000000000000004
R_1_17_6_3 Node1_17_6 Node2_17_6 10240.000000000002
R_1_17_7_1 Node1_17_7 Node1_17_8 2.5000000000000004
R_1_17_7_2 Node1_17_7 Node1_18_7 2.5000000000000004
R_1_17_7_3 Node1_17_7 Node2_17_7 10240.000000000002
R_1_17_8_1 Node1_17_8 Node1_17_9 2.5000000000000004
R_1_17_8_2 Node1_17_8 Node1_18_8 2.5000000000000004
R_1_17_8_3 Node1_17_8 Node2_17_8 10240.000000000002
R_1_17_9_1 Node1_17_9 Node1_17_10 2.5000000000000004
R_1_17_9_2 Node1_17_9 Node1_18_9 2.5000000000000004
R_1_17_9_3 Node1_17_9 Node2_17_9 10240.000000000002
R_1_17_10_1 Node1_17_10 Node1_17_11 2.5000000000000004
R_1_17_10_2 Node1_17_10 Node1_18_10 2.5000000000000004
R_1_17_10_3 Node1_17_10 Node2_17_10 10240.000000000002
R_1_17_11_1 Node1_17_11 Node1_17_12 2.5000000000000004
R_1_17_11_2 Node1_17_11 Node1_18_11 2.5000000000000004
R_1_17_11_3 Node1_17_11 Node2_17_11 10240.000000000002
R_1_17_12_1 Node1_17_12 Node1_17_13 2.5000000000000004
R_1_17_12_2 Node1_17_12 Node1_18_12 2.5000000000000004
R_1_17_12_3 Node1_17_12 Node2_17_12 10240.000000000002
R_1_17_13_1 Node1_17_13 Node1_17_14 2.5000000000000004
R_1_17_13_2 Node1_17_13 Node1_18_13 2.5000000000000004
R_1_17_13_3 Node1_17_13 Node2_17_13 10240.000000000002
R_1_17_14_1 Node1_17_14 Node1_17_15 2.5000000000000004
R_1_17_14_2 Node1_17_14 Node1_18_14 2.5000000000000004
R_1_17_14_3 Node1_17_14 Node2_17_14 10240.000000000002
R_1_17_15_1 Node1_17_15 Node1_17_16 2.5000000000000004
R_1_17_15_2 Node1_17_15 Node1_18_15 2.5000000000000004
R_1_17_15_3 Node1_17_15 Node2_17_15 10240.000000000002
R_1_17_16_1 Node1_17_16 Node1_17_17 2.5000000000000004
R_1_17_16_2 Node1_17_16 Node1_18_16 2.5000000000000004
R_1_17_16_3 Node1_17_16 Node2_17_16 10240.000000000002
R_1_17_17_1 Node1_17_17 Node1_17_18 2.5000000000000004
R_1_17_17_2 Node1_17_17 Node1_18_17 2.5000000000000004
R_1_17_17_3 Node1_17_17 Node2_17_17 10240.000000000002
R_1_17_18_1 Node1_17_18 Node1_17_19 2.5000000000000004
R_1_17_18_2 Node1_17_18 Node1_18_18 2.5000000000000004
R_1_17_18_3 Node1_17_18 Node2_17_18 10240.000000000002
R_1_17_19_1 Node1_17_19 Node1_17_20 2.5000000000000004
R_1_17_19_2 Node1_17_19 Node1_18_19 2.5000000000000004
R_1_17_19_3 Node1_17_19 Node2_17_19 10240.000000000002
R_1_17_20_1 Node1_17_20 Node1_17_21 2.5000000000000004
R_1_17_20_2 Node1_17_20 Node1_18_20 2.5000000000000004
R_1_17_20_3 Node1_17_20 Node2_17_20 10240.000000000002
R_1_17_21_1 Node1_17_21 Node1_17_22 2.5000000000000004
R_1_17_21_2 Node1_17_21 Node1_18_21 2.5000000000000004
R_1_17_21_3 Node1_17_21 Node2_17_21 10240.000000000002
R_1_17_22_1 Node1_17_22 Node1_17_23 2.5000000000000004
R_1_17_22_2 Node1_17_22 Node1_18_22 2.5000000000000004
R_1_17_22_3 Node1_17_22 Node2_17_22 10240.000000000002
R_1_17_23_1 Node1_17_23 Node1_17_24 2.5000000000000004
R_1_17_23_2 Node1_17_23 Node1_18_23 2.5000000000000004
R_1_17_23_3 Node1_17_23 Node2_17_23 10240.000000000002
R_1_17_24_1 Node1_17_24 Node1_17_25 2.5000000000000004
R_1_17_24_2 Node1_17_24 Node1_18_24 2.5000000000000004
R_1_17_24_3 Node1_17_24 Node2_17_24 10240.000000000002
R_1_17_25_1 Node1_17_25 Node1_17_26 2.5000000000000004
R_1_17_25_2 Node1_17_25 Node1_18_25 2.5000000000000004
R_1_17_25_3 Node1_17_25 Node2_17_25 10240.000000000002
R_1_17_26_1 Node1_17_26 Node1_17_27 2.5000000000000004
R_1_17_26_2 Node1_17_26 Node1_18_26 2.5000000000000004
R_1_17_26_3 Node1_17_26 Node2_17_26 10240.000000000002
R_1_17_27_1 Node1_17_27 Node1_17_28 2.5000000000000004
R_1_17_27_2 Node1_17_27 Node1_18_27 2.5000000000000004
R_1_17_27_3 Node1_17_27 Node2_17_27 10240.000000000002
R_1_17_28_1 Node1_17_28 Node1_17_29 2.5000000000000004
R_1_17_28_2 Node1_17_28 Node1_18_28 2.5000000000000004
R_1_17_28_3 Node1_17_28 Node2_17_28 10240.000000000002
R_1_17_29_1 Node1_17_29 Node1_17_30 2.5000000000000004
R_1_17_29_2 Node1_17_29 Node1_18_29 2.5000000000000004
R_1_17_29_3 Node1_17_29 Node2_17_29 10240.000000000002
R_1_17_30_1 Node1_17_30 Node1_17_31 2.5000000000000004
R_1_17_30_2 Node1_17_30 Node1_18_30 2.5000000000000004
R_1_17_30_3 Node1_17_30 Node2_17_30 10240.000000000002
Rsp_1_17_31_1 Node1_17_31 Node_sp_right 71.54069767441861
R_1_17_31_2 Node1_17_31 Node1_18_31 2.5000000000000004
R_1_17_31_3 Node1_17_31 Node2_17_31 10240.000000000002
R_1_18_0_1 Node1_18_0 Node1_18_1 2.5000000000000004
Rsp_1_18_0_1 Node1_18_0 Node_sp_left 71.54069767441861
R_1_18_0_2 Node1_18_0 Node1_19_0 2.5000000000000004
R_1_18_0_3 Node1_18_0 Node2_18_0 10240.000000000002
R_1_18_1_1 Node1_18_1 Node1_18_2 2.5000000000000004
R_1_18_1_2 Node1_18_1 Node1_19_1 2.5000000000000004
R_1_18_1_3 Node1_18_1 Node2_18_1 10240.000000000002
R_1_18_2_1 Node1_18_2 Node1_18_3 2.5000000000000004
R_1_18_2_2 Node1_18_2 Node1_19_2 2.5000000000000004
R_1_18_2_3 Node1_18_2 Node2_18_2 10240.000000000002
R_1_18_3_1 Node1_18_3 Node1_18_4 2.5000000000000004
R_1_18_3_2 Node1_18_3 Node1_19_3 2.5000000000000004
R_1_18_3_3 Node1_18_3 Node2_18_3 10240.000000000002
R_1_18_4_1 Node1_18_4 Node1_18_5 2.5000000000000004
R_1_18_4_2 Node1_18_4 Node1_19_4 2.5000000000000004
R_1_18_4_3 Node1_18_4 Node2_18_4 10240.000000000002
R_1_18_5_1 Node1_18_5 Node1_18_6 2.5000000000000004
R_1_18_5_2 Node1_18_5 Node1_19_5 2.5000000000000004
R_1_18_5_3 Node1_18_5 Node2_18_5 10240.000000000002
R_1_18_6_1 Node1_18_6 Node1_18_7 2.5000000000000004
R_1_18_6_2 Node1_18_6 Node1_19_6 2.5000000000000004
R_1_18_6_3 Node1_18_6 Node2_18_6 10240.000000000002
R_1_18_7_1 Node1_18_7 Node1_18_8 2.5000000000000004
R_1_18_7_2 Node1_18_7 Node1_19_7 2.5000000000000004
R_1_18_7_3 Node1_18_7 Node2_18_7 10240.000000000002
R_1_18_8_1 Node1_18_8 Node1_18_9 2.5000000000000004
R_1_18_8_2 Node1_18_8 Node1_19_8 2.5000000000000004
R_1_18_8_3 Node1_18_8 Node2_18_8 10240.000000000002
R_1_18_9_1 Node1_18_9 Node1_18_10 2.5000000000000004
R_1_18_9_2 Node1_18_9 Node1_19_9 2.5000000000000004
R_1_18_9_3 Node1_18_9 Node2_18_9 10240.000000000002
R_1_18_10_1 Node1_18_10 Node1_18_11 2.5000000000000004
R_1_18_10_2 Node1_18_10 Node1_19_10 2.5000000000000004
R_1_18_10_3 Node1_18_10 Node2_18_10 10240.000000000002
R_1_18_11_1 Node1_18_11 Node1_18_12 2.5000000000000004
R_1_18_11_2 Node1_18_11 Node1_19_11 2.5000000000000004
R_1_18_11_3 Node1_18_11 Node2_18_11 10240.000000000002
R_1_18_12_1 Node1_18_12 Node1_18_13 2.5000000000000004
R_1_18_12_2 Node1_18_12 Node1_19_12 2.5000000000000004
R_1_18_12_3 Node1_18_12 Node2_18_12 10240.000000000002
R_1_18_13_1 Node1_18_13 Node1_18_14 2.5000000000000004
R_1_18_13_2 Node1_18_13 Node1_19_13 2.5000000000000004
R_1_18_13_3 Node1_18_13 Node2_18_13 10240.000000000002
R_1_18_14_1 Node1_18_14 Node1_18_15 2.5000000000000004
R_1_18_14_2 Node1_18_14 Node1_19_14 2.5000000000000004
R_1_18_14_3 Node1_18_14 Node2_18_14 10240.000000000002
R_1_18_15_1 Node1_18_15 Node1_18_16 2.5000000000000004
R_1_18_15_2 Node1_18_15 Node1_19_15 2.5000000000000004
R_1_18_15_3 Node1_18_15 Node2_18_15 10240.000000000002
R_1_18_16_1 Node1_18_16 Node1_18_17 2.5000000000000004
R_1_18_16_2 Node1_18_16 Node1_19_16 2.5000000000000004
R_1_18_16_3 Node1_18_16 Node2_18_16 10240.000000000002
R_1_18_17_1 Node1_18_17 Node1_18_18 2.5000000000000004
R_1_18_17_2 Node1_18_17 Node1_19_17 2.5000000000000004
R_1_18_17_3 Node1_18_17 Node2_18_17 10240.000000000002
R_1_18_18_1 Node1_18_18 Node1_18_19 2.5000000000000004
R_1_18_18_2 Node1_18_18 Node1_19_18 2.5000000000000004
R_1_18_18_3 Node1_18_18 Node2_18_18 10240.000000000002
R_1_18_19_1 Node1_18_19 Node1_18_20 2.5000000000000004
R_1_18_19_2 Node1_18_19 Node1_19_19 2.5000000000000004
R_1_18_19_3 Node1_18_19 Node2_18_19 10240.000000000002
R_1_18_20_1 Node1_18_20 Node1_18_21 2.5000000000000004
R_1_18_20_2 Node1_18_20 Node1_19_20 2.5000000000000004
R_1_18_20_3 Node1_18_20 Node2_18_20 10240.000000000002
R_1_18_21_1 Node1_18_21 Node1_18_22 2.5000000000000004
R_1_18_21_2 Node1_18_21 Node1_19_21 2.5000000000000004
R_1_18_21_3 Node1_18_21 Node2_18_21 10240.000000000002
R_1_18_22_1 Node1_18_22 Node1_18_23 2.5000000000000004
R_1_18_22_2 Node1_18_22 Node1_19_22 2.5000000000000004
R_1_18_22_3 Node1_18_22 Node2_18_22 10240.000000000002
R_1_18_23_1 Node1_18_23 Node1_18_24 2.5000000000000004
R_1_18_23_2 Node1_18_23 Node1_19_23 2.5000000000000004
R_1_18_23_3 Node1_18_23 Node2_18_23 10240.000000000002
R_1_18_24_1 Node1_18_24 Node1_18_25 2.5000000000000004
R_1_18_24_2 Node1_18_24 Node1_19_24 2.5000000000000004
R_1_18_24_3 Node1_18_24 Node2_18_24 10240.000000000002
R_1_18_25_1 Node1_18_25 Node1_18_26 2.5000000000000004
R_1_18_25_2 Node1_18_25 Node1_19_25 2.5000000000000004
R_1_18_25_3 Node1_18_25 Node2_18_25 10240.000000000002
R_1_18_26_1 Node1_18_26 Node1_18_27 2.5000000000000004
R_1_18_26_2 Node1_18_26 Node1_19_26 2.5000000000000004
R_1_18_26_3 Node1_18_26 Node2_18_26 10240.000000000002
R_1_18_27_1 Node1_18_27 Node1_18_28 2.5000000000000004
R_1_18_27_2 Node1_18_27 Node1_19_27 2.5000000000000004
R_1_18_27_3 Node1_18_27 Node2_18_27 10240.000000000002
R_1_18_28_1 Node1_18_28 Node1_18_29 2.5000000000000004
R_1_18_28_2 Node1_18_28 Node1_19_28 2.5000000000000004
R_1_18_28_3 Node1_18_28 Node2_18_28 10240.000000000002
R_1_18_29_1 Node1_18_29 Node1_18_30 2.5000000000000004
R_1_18_29_2 Node1_18_29 Node1_19_29 2.5000000000000004
R_1_18_29_3 Node1_18_29 Node2_18_29 10240.000000000002
R_1_18_30_1 Node1_18_30 Node1_18_31 2.5000000000000004
R_1_18_30_2 Node1_18_30 Node1_19_30 2.5000000000000004
R_1_18_30_3 Node1_18_30 Node2_18_30 10240.000000000002
Rsp_1_18_31_1 Node1_18_31 Node_sp_right 71.54069767441861
R_1_18_31_2 Node1_18_31 Node1_19_31 2.5000000000000004
R_1_18_31_3 Node1_18_31 Node2_18_31 10240.000000000002
R_1_19_0_1 Node1_19_0 Node1_19_1 2.5000000000000004
Rsp_1_19_0_1 Node1_19_0 Node_sp_left 71.54069767441861
R_1_19_0_2 Node1_19_0 Node1_20_0 2.5000000000000004
R_1_19_0_3 Node1_19_0 Node2_19_0 10240.000000000002
R_1_19_1_1 Node1_19_1 Node1_19_2 2.5000000000000004
R_1_19_1_2 Node1_19_1 Node1_20_1 2.5000000000000004
R_1_19_1_3 Node1_19_1 Node2_19_1 10240.000000000002
R_1_19_2_1 Node1_19_2 Node1_19_3 2.5000000000000004
R_1_19_2_2 Node1_19_2 Node1_20_2 2.5000000000000004
R_1_19_2_3 Node1_19_2 Node2_19_2 10240.000000000002
R_1_19_3_1 Node1_19_3 Node1_19_4 2.5000000000000004
R_1_19_3_2 Node1_19_3 Node1_20_3 2.5000000000000004
R_1_19_3_3 Node1_19_3 Node2_19_3 10240.000000000002
R_1_19_4_1 Node1_19_4 Node1_19_5 2.5000000000000004
R_1_19_4_2 Node1_19_4 Node1_20_4 2.5000000000000004
R_1_19_4_3 Node1_19_4 Node2_19_4 10240.000000000002
R_1_19_5_1 Node1_19_5 Node1_19_6 2.5000000000000004
R_1_19_5_2 Node1_19_5 Node1_20_5 2.5000000000000004
R_1_19_5_3 Node1_19_5 Node2_19_5 10240.000000000002
R_1_19_6_1 Node1_19_6 Node1_19_7 2.5000000000000004
R_1_19_6_2 Node1_19_6 Node1_20_6 2.5000000000000004
R_1_19_6_3 Node1_19_6 Node2_19_6 10240.000000000002
R_1_19_7_1 Node1_19_7 Node1_19_8 2.5000000000000004
R_1_19_7_2 Node1_19_7 Node1_20_7 2.5000000000000004
R_1_19_7_3 Node1_19_7 Node2_19_7 10240.000000000002
R_1_19_8_1 Node1_19_8 Node1_19_9 2.5000000000000004
R_1_19_8_2 Node1_19_8 Node1_20_8 2.5000000000000004
R_1_19_8_3 Node1_19_8 Node2_19_8 10240.000000000002
R_1_19_9_1 Node1_19_9 Node1_19_10 2.5000000000000004
R_1_19_9_2 Node1_19_9 Node1_20_9 2.5000000000000004
R_1_19_9_3 Node1_19_9 Node2_19_9 10240.000000000002
R_1_19_10_1 Node1_19_10 Node1_19_11 2.5000000000000004
R_1_19_10_2 Node1_19_10 Node1_20_10 2.5000000000000004
R_1_19_10_3 Node1_19_10 Node2_19_10 10240.000000000002
R_1_19_11_1 Node1_19_11 Node1_19_12 2.5000000000000004
R_1_19_11_2 Node1_19_11 Node1_20_11 2.5000000000000004
R_1_19_11_3 Node1_19_11 Node2_19_11 10240.000000000002
R_1_19_12_1 Node1_19_12 Node1_19_13 2.5000000000000004
R_1_19_12_2 Node1_19_12 Node1_20_12 2.5000000000000004
R_1_19_12_3 Node1_19_12 Node2_19_12 10240.000000000002
R_1_19_13_1 Node1_19_13 Node1_19_14 2.5000000000000004
R_1_19_13_2 Node1_19_13 Node1_20_13 2.5000000000000004
R_1_19_13_3 Node1_19_13 Node2_19_13 10240.000000000002
R_1_19_14_1 Node1_19_14 Node1_19_15 2.5000000000000004
R_1_19_14_2 Node1_19_14 Node1_20_14 2.5000000000000004
R_1_19_14_3 Node1_19_14 Node2_19_14 10240.000000000002
R_1_19_15_1 Node1_19_15 Node1_19_16 2.5000000000000004
R_1_19_15_2 Node1_19_15 Node1_20_15 2.5000000000000004
R_1_19_15_3 Node1_19_15 Node2_19_15 10240.000000000002
R_1_19_16_1 Node1_19_16 Node1_19_17 2.5000000000000004
R_1_19_16_2 Node1_19_16 Node1_20_16 2.5000000000000004
R_1_19_16_3 Node1_19_16 Node2_19_16 10240.000000000002
R_1_19_17_1 Node1_19_17 Node1_19_18 2.5000000000000004
R_1_19_17_2 Node1_19_17 Node1_20_17 2.5000000000000004
R_1_19_17_3 Node1_19_17 Node2_19_17 10240.000000000002
R_1_19_18_1 Node1_19_18 Node1_19_19 2.5000000000000004
R_1_19_18_2 Node1_19_18 Node1_20_18 2.5000000000000004
R_1_19_18_3 Node1_19_18 Node2_19_18 10240.000000000002
R_1_19_19_1 Node1_19_19 Node1_19_20 2.5000000000000004
R_1_19_19_2 Node1_19_19 Node1_20_19 2.5000000000000004
R_1_19_19_3 Node1_19_19 Node2_19_19 10240.000000000002
R_1_19_20_1 Node1_19_20 Node1_19_21 2.5000000000000004
R_1_19_20_2 Node1_19_20 Node1_20_20 2.5000000000000004
R_1_19_20_3 Node1_19_20 Node2_19_20 10240.000000000002
R_1_19_21_1 Node1_19_21 Node1_19_22 2.5000000000000004
R_1_19_21_2 Node1_19_21 Node1_20_21 2.5000000000000004
R_1_19_21_3 Node1_19_21 Node2_19_21 10240.000000000002
R_1_19_22_1 Node1_19_22 Node1_19_23 2.5000000000000004
R_1_19_22_2 Node1_19_22 Node1_20_22 2.5000000000000004
R_1_19_22_3 Node1_19_22 Node2_19_22 10240.000000000002
R_1_19_23_1 Node1_19_23 Node1_19_24 2.5000000000000004
R_1_19_23_2 Node1_19_23 Node1_20_23 2.5000000000000004
R_1_19_23_3 Node1_19_23 Node2_19_23 10240.000000000002
R_1_19_24_1 Node1_19_24 Node1_19_25 2.5000000000000004
R_1_19_24_2 Node1_19_24 Node1_20_24 2.5000000000000004
R_1_19_24_3 Node1_19_24 Node2_19_24 10240.000000000002
R_1_19_25_1 Node1_19_25 Node1_19_26 2.5000000000000004
R_1_19_25_2 Node1_19_25 Node1_20_25 2.5000000000000004
R_1_19_25_3 Node1_19_25 Node2_19_25 10240.000000000002
R_1_19_26_1 Node1_19_26 Node1_19_27 2.5000000000000004
R_1_19_26_2 Node1_19_26 Node1_20_26 2.5000000000000004
R_1_19_26_3 Node1_19_26 Node2_19_26 10240.000000000002
R_1_19_27_1 Node1_19_27 Node1_19_28 2.5000000000000004
R_1_19_27_2 Node1_19_27 Node1_20_27 2.5000000000000004
R_1_19_27_3 Node1_19_27 Node2_19_27 10240.000000000002
R_1_19_28_1 Node1_19_28 Node1_19_29 2.5000000000000004
R_1_19_28_2 Node1_19_28 Node1_20_28 2.5000000000000004
R_1_19_28_3 Node1_19_28 Node2_19_28 10240.000000000002
R_1_19_29_1 Node1_19_29 Node1_19_30 2.5000000000000004
R_1_19_29_2 Node1_19_29 Node1_20_29 2.5000000000000004
R_1_19_29_3 Node1_19_29 Node2_19_29 10240.000000000002
R_1_19_30_1 Node1_19_30 Node1_19_31 2.5000000000000004
R_1_19_30_2 Node1_19_30 Node1_20_30 2.5000000000000004
R_1_19_30_3 Node1_19_30 Node2_19_30 10240.000000000002
Rsp_1_19_31_1 Node1_19_31 Node_sp_right 71.54069767441861
R_1_19_31_2 Node1_19_31 Node1_20_31 2.5000000000000004
R_1_19_31_3 Node1_19_31 Node2_19_31 10240.000000000002
R_1_20_0_1 Node1_20_0 Node1_20_1 2.5000000000000004
Rsp_1_20_0_1 Node1_20_0 Node_sp_left 71.54069767441861
R_1_20_0_2 Node1_20_0 Node1_21_0 2.5000000000000004
R_1_20_0_3 Node1_20_0 Node2_20_0 10240.000000000002
R_1_20_1_1 Node1_20_1 Node1_20_2 2.5000000000000004
R_1_20_1_2 Node1_20_1 Node1_21_1 2.5000000000000004
R_1_20_1_3 Node1_20_1 Node2_20_1 10240.000000000002
R_1_20_2_1 Node1_20_2 Node1_20_3 2.5000000000000004
R_1_20_2_2 Node1_20_2 Node1_21_2 2.5000000000000004
R_1_20_2_3 Node1_20_2 Node2_20_2 10240.000000000002
R_1_20_3_1 Node1_20_3 Node1_20_4 2.5000000000000004
R_1_20_3_2 Node1_20_3 Node1_21_3 2.5000000000000004
R_1_20_3_3 Node1_20_3 Node2_20_3 10240.000000000002
R_1_20_4_1 Node1_20_4 Node1_20_5 2.5000000000000004
R_1_20_4_2 Node1_20_4 Node1_21_4 2.5000000000000004
R_1_20_4_3 Node1_20_4 Node2_20_4 10240.000000000002
R_1_20_5_1 Node1_20_5 Node1_20_6 2.5000000000000004
R_1_20_5_2 Node1_20_5 Node1_21_5 2.5000000000000004
R_1_20_5_3 Node1_20_5 Node2_20_5 10240.000000000002
R_1_20_6_1 Node1_20_6 Node1_20_7 2.5000000000000004
R_1_20_6_2 Node1_20_6 Node1_21_6 2.5000000000000004
R_1_20_6_3 Node1_20_6 Node2_20_6 10240.000000000002
R_1_20_7_1 Node1_20_7 Node1_20_8 2.5000000000000004
R_1_20_7_2 Node1_20_7 Node1_21_7 2.5000000000000004
R_1_20_7_3 Node1_20_7 Node2_20_7 10240.000000000002
R_1_20_8_1 Node1_20_8 Node1_20_9 2.5000000000000004
R_1_20_8_2 Node1_20_8 Node1_21_8 2.5000000000000004
R_1_20_8_3 Node1_20_8 Node2_20_8 10240.000000000002
R_1_20_9_1 Node1_20_9 Node1_20_10 2.5000000000000004
R_1_20_9_2 Node1_20_9 Node1_21_9 2.5000000000000004
R_1_20_9_3 Node1_20_9 Node2_20_9 10240.000000000002
R_1_20_10_1 Node1_20_10 Node1_20_11 2.5000000000000004
R_1_20_10_2 Node1_20_10 Node1_21_10 2.5000000000000004
R_1_20_10_3 Node1_20_10 Node2_20_10 10240.000000000002
R_1_20_11_1 Node1_20_11 Node1_20_12 2.5000000000000004
R_1_20_11_2 Node1_20_11 Node1_21_11 2.5000000000000004
R_1_20_11_3 Node1_20_11 Node2_20_11 10240.000000000002
R_1_20_12_1 Node1_20_12 Node1_20_13 2.5000000000000004
R_1_20_12_2 Node1_20_12 Node1_21_12 2.5000000000000004
R_1_20_12_3 Node1_20_12 Node2_20_12 10240.000000000002
R_1_20_13_1 Node1_20_13 Node1_20_14 2.5000000000000004
R_1_20_13_2 Node1_20_13 Node1_21_13 2.5000000000000004
R_1_20_13_3 Node1_20_13 Node2_20_13 10240.000000000002
R_1_20_14_1 Node1_20_14 Node1_20_15 2.5000000000000004
R_1_20_14_2 Node1_20_14 Node1_21_14 2.5000000000000004
R_1_20_14_3 Node1_20_14 Node2_20_14 10240.000000000002
R_1_20_15_1 Node1_20_15 Node1_20_16 2.5000000000000004
R_1_20_15_2 Node1_20_15 Node1_21_15 2.5000000000000004
R_1_20_15_3 Node1_20_15 Node2_20_15 10240.000000000002
R_1_20_16_1 Node1_20_16 Node1_20_17 2.5000000000000004
R_1_20_16_2 Node1_20_16 Node1_21_16 2.5000000000000004
R_1_20_16_3 Node1_20_16 Node2_20_16 10240.000000000002
R_1_20_17_1 Node1_20_17 Node1_20_18 2.5000000000000004
R_1_20_17_2 Node1_20_17 Node1_21_17 2.5000000000000004
R_1_20_17_3 Node1_20_17 Node2_20_17 10240.000000000002
R_1_20_18_1 Node1_20_18 Node1_20_19 2.5000000000000004
R_1_20_18_2 Node1_20_18 Node1_21_18 2.5000000000000004
R_1_20_18_3 Node1_20_18 Node2_20_18 10240.000000000002
R_1_20_19_1 Node1_20_19 Node1_20_20 2.5000000000000004
R_1_20_19_2 Node1_20_19 Node1_21_19 2.5000000000000004
R_1_20_19_3 Node1_20_19 Node2_20_19 10240.000000000002
R_1_20_20_1 Node1_20_20 Node1_20_21 2.5000000000000004
R_1_20_20_2 Node1_20_20 Node1_21_20 2.5000000000000004
R_1_20_20_3 Node1_20_20 Node2_20_20 10240.000000000002
R_1_20_21_1 Node1_20_21 Node1_20_22 2.5000000000000004
R_1_20_21_2 Node1_20_21 Node1_21_21 2.5000000000000004
R_1_20_21_3 Node1_20_21 Node2_20_21 10240.000000000002
R_1_20_22_1 Node1_20_22 Node1_20_23 2.5000000000000004
R_1_20_22_2 Node1_20_22 Node1_21_22 2.5000000000000004
R_1_20_22_3 Node1_20_22 Node2_20_22 10240.000000000002
R_1_20_23_1 Node1_20_23 Node1_20_24 2.5000000000000004
R_1_20_23_2 Node1_20_23 Node1_21_23 2.5000000000000004
R_1_20_23_3 Node1_20_23 Node2_20_23 10240.000000000002
R_1_20_24_1 Node1_20_24 Node1_20_25 2.5000000000000004
R_1_20_24_2 Node1_20_24 Node1_21_24 2.5000000000000004
R_1_20_24_3 Node1_20_24 Node2_20_24 10240.000000000002
R_1_20_25_1 Node1_20_25 Node1_20_26 2.5000000000000004
R_1_20_25_2 Node1_20_25 Node1_21_25 2.5000000000000004
R_1_20_25_3 Node1_20_25 Node2_20_25 10240.000000000002
R_1_20_26_1 Node1_20_26 Node1_20_27 2.5000000000000004
R_1_20_26_2 Node1_20_26 Node1_21_26 2.5000000000000004
R_1_20_26_3 Node1_20_26 Node2_20_26 10240.000000000002
R_1_20_27_1 Node1_20_27 Node1_20_28 2.5000000000000004
R_1_20_27_2 Node1_20_27 Node1_21_27 2.5000000000000004
R_1_20_27_3 Node1_20_27 Node2_20_27 10240.000000000002
R_1_20_28_1 Node1_20_28 Node1_20_29 2.5000000000000004
R_1_20_28_2 Node1_20_28 Node1_21_28 2.5000000000000004
R_1_20_28_3 Node1_20_28 Node2_20_28 10240.000000000002
R_1_20_29_1 Node1_20_29 Node1_20_30 2.5000000000000004
R_1_20_29_2 Node1_20_29 Node1_21_29 2.5000000000000004
R_1_20_29_3 Node1_20_29 Node2_20_29 10240.000000000002
R_1_20_30_1 Node1_20_30 Node1_20_31 2.5000000000000004
R_1_20_30_2 Node1_20_30 Node1_21_30 2.5000000000000004
R_1_20_30_3 Node1_20_30 Node2_20_30 10240.000000000002
Rsp_1_20_31_1 Node1_20_31 Node_sp_right 71.54069767441861
R_1_20_31_2 Node1_20_31 Node1_21_31 2.5000000000000004
R_1_20_31_3 Node1_20_31 Node2_20_31 10240.000000000002
R_1_21_0_1 Node1_21_0 Node1_21_1 2.5000000000000004
Rsp_1_21_0_1 Node1_21_0 Node_sp_left 71.54069767441861
R_1_21_0_2 Node1_21_0 Node1_22_0 2.5000000000000004
R_1_21_0_3 Node1_21_0 Node2_21_0 10240.000000000002
R_1_21_1_1 Node1_21_1 Node1_21_2 2.5000000000000004
R_1_21_1_2 Node1_21_1 Node1_22_1 2.5000000000000004
R_1_21_1_3 Node1_21_1 Node2_21_1 10240.000000000002
R_1_21_2_1 Node1_21_2 Node1_21_3 2.5000000000000004
R_1_21_2_2 Node1_21_2 Node1_22_2 2.5000000000000004
R_1_21_2_3 Node1_21_2 Node2_21_2 10240.000000000002
R_1_21_3_1 Node1_21_3 Node1_21_4 2.5000000000000004
R_1_21_3_2 Node1_21_3 Node1_22_3 2.5000000000000004
R_1_21_3_3 Node1_21_3 Node2_21_3 10240.000000000002
R_1_21_4_1 Node1_21_4 Node1_21_5 2.5000000000000004
R_1_21_4_2 Node1_21_4 Node1_22_4 2.5000000000000004
R_1_21_4_3 Node1_21_4 Node2_21_4 10240.000000000002
R_1_21_5_1 Node1_21_5 Node1_21_6 2.5000000000000004
R_1_21_5_2 Node1_21_5 Node1_22_5 2.5000000000000004
R_1_21_5_3 Node1_21_5 Node2_21_5 10240.000000000002
R_1_21_6_1 Node1_21_6 Node1_21_7 2.5000000000000004
R_1_21_6_2 Node1_21_6 Node1_22_6 2.5000000000000004
R_1_21_6_3 Node1_21_6 Node2_21_6 10240.000000000002
R_1_21_7_1 Node1_21_7 Node1_21_8 2.5000000000000004
R_1_21_7_2 Node1_21_7 Node1_22_7 2.5000000000000004
R_1_21_7_3 Node1_21_7 Node2_21_7 10240.000000000002
R_1_21_8_1 Node1_21_8 Node1_21_9 2.5000000000000004
R_1_21_8_2 Node1_21_8 Node1_22_8 2.5000000000000004
R_1_21_8_3 Node1_21_8 Node2_21_8 10240.000000000002
R_1_21_9_1 Node1_21_9 Node1_21_10 2.5000000000000004
R_1_21_9_2 Node1_21_9 Node1_22_9 2.5000000000000004
R_1_21_9_3 Node1_21_9 Node2_21_9 10240.000000000002
R_1_21_10_1 Node1_21_10 Node1_21_11 2.5000000000000004
R_1_21_10_2 Node1_21_10 Node1_22_10 2.5000000000000004
R_1_21_10_3 Node1_21_10 Node2_21_10 10240.000000000002
R_1_21_11_1 Node1_21_11 Node1_21_12 2.5000000000000004
R_1_21_11_2 Node1_21_11 Node1_22_11 2.5000000000000004
R_1_21_11_3 Node1_21_11 Node2_21_11 10240.000000000002
R_1_21_12_1 Node1_21_12 Node1_21_13 2.5000000000000004
R_1_21_12_2 Node1_21_12 Node1_22_12 2.5000000000000004
R_1_21_12_3 Node1_21_12 Node2_21_12 10240.000000000002
R_1_21_13_1 Node1_21_13 Node1_21_14 2.5000000000000004
R_1_21_13_2 Node1_21_13 Node1_22_13 2.5000000000000004
R_1_21_13_3 Node1_21_13 Node2_21_13 10240.000000000002
R_1_21_14_1 Node1_21_14 Node1_21_15 2.5000000000000004
R_1_21_14_2 Node1_21_14 Node1_22_14 2.5000000000000004
R_1_21_14_3 Node1_21_14 Node2_21_14 10240.000000000002
R_1_21_15_1 Node1_21_15 Node1_21_16 2.5000000000000004
R_1_21_15_2 Node1_21_15 Node1_22_15 2.5000000000000004
R_1_21_15_3 Node1_21_15 Node2_21_15 10240.000000000002
R_1_21_16_1 Node1_21_16 Node1_21_17 2.5000000000000004
R_1_21_16_2 Node1_21_16 Node1_22_16 2.5000000000000004
R_1_21_16_3 Node1_21_16 Node2_21_16 10240.000000000002
R_1_21_17_1 Node1_21_17 Node1_21_18 2.5000000000000004
R_1_21_17_2 Node1_21_17 Node1_22_17 2.5000000000000004
R_1_21_17_3 Node1_21_17 Node2_21_17 10240.000000000002
R_1_21_18_1 Node1_21_18 Node1_21_19 2.5000000000000004
R_1_21_18_2 Node1_21_18 Node1_22_18 2.5000000000000004
R_1_21_18_3 Node1_21_18 Node2_21_18 10240.000000000002
R_1_21_19_1 Node1_21_19 Node1_21_20 2.5000000000000004
R_1_21_19_2 Node1_21_19 Node1_22_19 2.5000000000000004
R_1_21_19_3 Node1_21_19 Node2_21_19 10240.000000000002
R_1_21_20_1 Node1_21_20 Node1_21_21 2.5000000000000004
R_1_21_20_2 Node1_21_20 Node1_22_20 2.5000000000000004
R_1_21_20_3 Node1_21_20 Node2_21_20 10240.000000000002
R_1_21_21_1 Node1_21_21 Node1_21_22 2.5000000000000004
R_1_21_21_2 Node1_21_21 Node1_22_21 2.5000000000000004
R_1_21_21_3 Node1_21_21 Node2_21_21 10240.000000000002
R_1_21_22_1 Node1_21_22 Node1_21_23 2.5000000000000004
R_1_21_22_2 Node1_21_22 Node1_22_22 2.5000000000000004
R_1_21_22_3 Node1_21_22 Node2_21_22 10240.000000000002
R_1_21_23_1 Node1_21_23 Node1_21_24 2.5000000000000004
R_1_21_23_2 Node1_21_23 Node1_22_23 2.5000000000000004
R_1_21_23_3 Node1_21_23 Node2_21_23 10240.000000000002
R_1_21_24_1 Node1_21_24 Node1_21_25 2.5000000000000004
R_1_21_24_2 Node1_21_24 Node1_22_24 2.5000000000000004
R_1_21_24_3 Node1_21_24 Node2_21_24 10240.000000000002
R_1_21_25_1 Node1_21_25 Node1_21_26 2.5000000000000004
R_1_21_25_2 Node1_21_25 Node1_22_25 2.5000000000000004
R_1_21_25_3 Node1_21_25 Node2_21_25 10240.000000000002
R_1_21_26_1 Node1_21_26 Node1_21_27 2.5000000000000004
R_1_21_26_2 Node1_21_26 Node1_22_26 2.5000000000000004
R_1_21_26_3 Node1_21_26 Node2_21_26 10240.000000000002
R_1_21_27_1 Node1_21_27 Node1_21_28 2.5000000000000004
R_1_21_27_2 Node1_21_27 Node1_22_27 2.5000000000000004
R_1_21_27_3 Node1_21_27 Node2_21_27 10240.000000000002
R_1_21_28_1 Node1_21_28 Node1_21_29 2.5000000000000004
R_1_21_28_2 Node1_21_28 Node1_22_28 2.5000000000000004
R_1_21_28_3 Node1_21_28 Node2_21_28 10240.000000000002
R_1_21_29_1 Node1_21_29 Node1_21_30 2.5000000000000004
R_1_21_29_2 Node1_21_29 Node1_22_29 2.5000000000000004
R_1_21_29_3 Node1_21_29 Node2_21_29 10240.000000000002
R_1_21_30_1 Node1_21_30 Node1_21_31 2.5000000000000004
R_1_21_30_2 Node1_21_30 Node1_22_30 2.5000000000000004
R_1_21_30_3 Node1_21_30 Node2_21_30 10240.000000000002
Rsp_1_21_31_1 Node1_21_31 Node_sp_right 71.54069767441861
R_1_21_31_2 Node1_21_31 Node1_22_31 2.5000000000000004
R_1_21_31_3 Node1_21_31 Node2_21_31 10240.000000000002
R_1_22_0_1 Node1_22_0 Node1_22_1 2.5000000000000004
Rsp_1_22_0_1 Node1_22_0 Node_sp_left 71.54069767441861
R_1_22_0_2 Node1_22_0 Node1_23_0 2.5000000000000004
R_1_22_0_3 Node1_22_0 Node2_22_0 10240.000000000002
R_1_22_1_1 Node1_22_1 Node1_22_2 2.5000000000000004
R_1_22_1_2 Node1_22_1 Node1_23_1 2.5000000000000004
R_1_22_1_3 Node1_22_1 Node2_22_1 10240.000000000002
R_1_22_2_1 Node1_22_2 Node1_22_3 2.5000000000000004
R_1_22_2_2 Node1_22_2 Node1_23_2 2.5000000000000004
R_1_22_2_3 Node1_22_2 Node2_22_2 10240.000000000002
R_1_22_3_1 Node1_22_3 Node1_22_4 2.5000000000000004
R_1_22_3_2 Node1_22_3 Node1_23_3 2.5000000000000004
R_1_22_3_3 Node1_22_3 Node2_22_3 10240.000000000002
R_1_22_4_1 Node1_22_4 Node1_22_5 2.5000000000000004
R_1_22_4_2 Node1_22_4 Node1_23_4 2.5000000000000004
R_1_22_4_3 Node1_22_4 Node2_22_4 10240.000000000002
R_1_22_5_1 Node1_22_5 Node1_22_6 2.5000000000000004
R_1_22_5_2 Node1_22_5 Node1_23_5 2.5000000000000004
R_1_22_5_3 Node1_22_5 Node2_22_5 10240.000000000002
R_1_22_6_1 Node1_22_6 Node1_22_7 2.5000000000000004
R_1_22_6_2 Node1_22_6 Node1_23_6 2.5000000000000004
R_1_22_6_3 Node1_22_6 Node2_22_6 10240.000000000002
R_1_22_7_1 Node1_22_7 Node1_22_8 2.5000000000000004
R_1_22_7_2 Node1_22_7 Node1_23_7 2.5000000000000004
R_1_22_7_3 Node1_22_7 Node2_22_7 10240.000000000002
R_1_22_8_1 Node1_22_8 Node1_22_9 2.5000000000000004
R_1_22_8_2 Node1_22_8 Node1_23_8 2.5000000000000004
R_1_22_8_3 Node1_22_8 Node2_22_8 10240.000000000002
R_1_22_9_1 Node1_22_9 Node1_22_10 2.5000000000000004
R_1_22_9_2 Node1_22_9 Node1_23_9 2.5000000000000004
R_1_22_9_3 Node1_22_9 Node2_22_9 10240.000000000002
R_1_22_10_1 Node1_22_10 Node1_22_11 2.5000000000000004
R_1_22_10_2 Node1_22_10 Node1_23_10 2.5000000000000004
R_1_22_10_3 Node1_22_10 Node2_22_10 10240.000000000002
R_1_22_11_1 Node1_22_11 Node1_22_12 2.5000000000000004
R_1_22_11_2 Node1_22_11 Node1_23_11 2.5000000000000004
R_1_22_11_3 Node1_22_11 Node2_22_11 10240.000000000002
R_1_22_12_1 Node1_22_12 Node1_22_13 2.5000000000000004
R_1_22_12_2 Node1_22_12 Node1_23_12 2.5000000000000004
R_1_22_12_3 Node1_22_12 Node2_22_12 10240.000000000002
R_1_22_13_1 Node1_22_13 Node1_22_14 2.5000000000000004
R_1_22_13_2 Node1_22_13 Node1_23_13 2.5000000000000004
R_1_22_13_3 Node1_22_13 Node2_22_13 10240.000000000002
R_1_22_14_1 Node1_22_14 Node1_22_15 2.5000000000000004
R_1_22_14_2 Node1_22_14 Node1_23_14 2.5000000000000004
R_1_22_14_3 Node1_22_14 Node2_22_14 10240.000000000002
R_1_22_15_1 Node1_22_15 Node1_22_16 2.5000000000000004
R_1_22_15_2 Node1_22_15 Node1_23_15 2.5000000000000004
R_1_22_15_3 Node1_22_15 Node2_22_15 10240.000000000002
R_1_22_16_1 Node1_22_16 Node1_22_17 2.5000000000000004
R_1_22_16_2 Node1_22_16 Node1_23_16 2.5000000000000004
R_1_22_16_3 Node1_22_16 Node2_22_16 10240.000000000002
R_1_22_17_1 Node1_22_17 Node1_22_18 2.5000000000000004
R_1_22_17_2 Node1_22_17 Node1_23_17 2.5000000000000004
R_1_22_17_3 Node1_22_17 Node2_22_17 10240.000000000002
R_1_22_18_1 Node1_22_18 Node1_22_19 2.5000000000000004
R_1_22_18_2 Node1_22_18 Node1_23_18 2.5000000000000004
R_1_22_18_3 Node1_22_18 Node2_22_18 10240.000000000002
R_1_22_19_1 Node1_22_19 Node1_22_20 2.5000000000000004
R_1_22_19_2 Node1_22_19 Node1_23_19 2.5000000000000004
R_1_22_19_3 Node1_22_19 Node2_22_19 10240.000000000002
R_1_22_20_1 Node1_22_20 Node1_22_21 2.5000000000000004
R_1_22_20_2 Node1_22_20 Node1_23_20 2.5000000000000004
R_1_22_20_3 Node1_22_20 Node2_22_20 10240.000000000002
R_1_22_21_1 Node1_22_21 Node1_22_22 2.5000000000000004
R_1_22_21_2 Node1_22_21 Node1_23_21 2.5000000000000004
R_1_22_21_3 Node1_22_21 Node2_22_21 10240.000000000002
R_1_22_22_1 Node1_22_22 Node1_22_23 2.5000000000000004
R_1_22_22_2 Node1_22_22 Node1_23_22 2.5000000000000004
R_1_22_22_3 Node1_22_22 Node2_22_22 10240.000000000002
R_1_22_23_1 Node1_22_23 Node1_22_24 2.5000000000000004
R_1_22_23_2 Node1_22_23 Node1_23_23 2.5000000000000004
R_1_22_23_3 Node1_22_23 Node2_22_23 10240.000000000002
R_1_22_24_1 Node1_22_24 Node1_22_25 2.5000000000000004
R_1_22_24_2 Node1_22_24 Node1_23_24 2.5000000000000004
R_1_22_24_3 Node1_22_24 Node2_22_24 10240.000000000002
R_1_22_25_1 Node1_22_25 Node1_22_26 2.5000000000000004
R_1_22_25_2 Node1_22_25 Node1_23_25 2.5000000000000004
R_1_22_25_3 Node1_22_25 Node2_22_25 10240.000000000002
R_1_22_26_1 Node1_22_26 Node1_22_27 2.5000000000000004
R_1_22_26_2 Node1_22_26 Node1_23_26 2.5000000000000004
R_1_22_26_3 Node1_22_26 Node2_22_26 10240.000000000002
R_1_22_27_1 Node1_22_27 Node1_22_28 2.5000000000000004
R_1_22_27_2 Node1_22_27 Node1_23_27 2.5000000000000004
R_1_22_27_3 Node1_22_27 Node2_22_27 10240.000000000002
R_1_22_28_1 Node1_22_28 Node1_22_29 2.5000000000000004
R_1_22_28_2 Node1_22_28 Node1_23_28 2.5000000000000004
R_1_22_28_3 Node1_22_28 Node2_22_28 10240.000000000002
R_1_22_29_1 Node1_22_29 Node1_22_30 2.5000000000000004
R_1_22_29_2 Node1_22_29 Node1_23_29 2.5000000000000004
R_1_22_29_3 Node1_22_29 Node2_22_29 10240.000000000002
R_1_22_30_1 Node1_22_30 Node1_22_31 2.5000000000000004
R_1_22_30_2 Node1_22_30 Node1_23_30 2.5000000000000004
R_1_22_30_3 Node1_22_30 Node2_22_30 10240.000000000002
Rsp_1_22_31_1 Node1_22_31 Node_sp_right 71.54069767441861
R_1_22_31_2 Node1_22_31 Node1_23_31 2.5000000000000004
R_1_22_31_3 Node1_22_31 Node2_22_31 10240.000000000002
R_1_23_0_1 Node1_23_0 Node1_23_1 2.5000000000000004
Rsp_1_23_0_1 Node1_23_0 Node_sp_left 71.54069767441861
R_1_23_0_2 Node1_23_0 Node1_24_0 2.5000000000000004
R_1_23_0_3 Node1_23_0 Node2_23_0 10240.000000000002
R_1_23_1_1 Node1_23_1 Node1_23_2 2.5000000000000004
R_1_23_1_2 Node1_23_1 Node1_24_1 2.5000000000000004
R_1_23_1_3 Node1_23_1 Node2_23_1 10240.000000000002
R_1_23_2_1 Node1_23_2 Node1_23_3 2.5000000000000004
R_1_23_2_2 Node1_23_2 Node1_24_2 2.5000000000000004
R_1_23_2_3 Node1_23_2 Node2_23_2 10240.000000000002
R_1_23_3_1 Node1_23_3 Node1_23_4 2.5000000000000004
R_1_23_3_2 Node1_23_3 Node1_24_3 2.5000000000000004
R_1_23_3_3 Node1_23_3 Node2_23_3 10240.000000000002
R_1_23_4_1 Node1_23_4 Node1_23_5 2.5000000000000004
R_1_23_4_2 Node1_23_4 Node1_24_4 2.5000000000000004
R_1_23_4_3 Node1_23_4 Node2_23_4 10240.000000000002
R_1_23_5_1 Node1_23_5 Node1_23_6 2.5000000000000004
R_1_23_5_2 Node1_23_5 Node1_24_5 2.5000000000000004
R_1_23_5_3 Node1_23_5 Node2_23_5 10240.000000000002
R_1_23_6_1 Node1_23_6 Node1_23_7 2.5000000000000004
R_1_23_6_2 Node1_23_6 Node1_24_6 2.5000000000000004
R_1_23_6_3 Node1_23_6 Node2_23_6 10240.000000000002
R_1_23_7_1 Node1_23_7 Node1_23_8 2.5000000000000004
R_1_23_7_2 Node1_23_7 Node1_24_7 2.5000000000000004
R_1_23_7_3 Node1_23_7 Node2_23_7 10240.000000000002
R_1_23_8_1 Node1_23_8 Node1_23_9 2.5000000000000004
R_1_23_8_2 Node1_23_8 Node1_24_8 2.5000000000000004
R_1_23_8_3 Node1_23_8 Node2_23_8 10240.000000000002
R_1_23_9_1 Node1_23_9 Node1_23_10 2.5000000000000004
R_1_23_9_2 Node1_23_9 Node1_24_9 2.5000000000000004
R_1_23_9_3 Node1_23_9 Node2_23_9 10240.000000000002
R_1_23_10_1 Node1_23_10 Node1_23_11 2.5000000000000004
R_1_23_10_2 Node1_23_10 Node1_24_10 2.5000000000000004
R_1_23_10_3 Node1_23_10 Node2_23_10 10240.000000000002
R_1_23_11_1 Node1_23_11 Node1_23_12 2.5000000000000004
R_1_23_11_2 Node1_23_11 Node1_24_11 2.5000000000000004
R_1_23_11_3 Node1_23_11 Node2_23_11 10240.000000000002
R_1_23_12_1 Node1_23_12 Node1_23_13 2.5000000000000004
R_1_23_12_2 Node1_23_12 Node1_24_12 2.5000000000000004
R_1_23_12_3 Node1_23_12 Node2_23_12 10240.000000000002
R_1_23_13_1 Node1_23_13 Node1_23_14 2.5000000000000004
R_1_23_13_2 Node1_23_13 Node1_24_13 2.5000000000000004
R_1_23_13_3 Node1_23_13 Node2_23_13 10240.000000000002
R_1_23_14_1 Node1_23_14 Node1_23_15 2.5000000000000004
R_1_23_14_2 Node1_23_14 Node1_24_14 2.5000000000000004
R_1_23_14_3 Node1_23_14 Node2_23_14 10240.000000000002
R_1_23_15_1 Node1_23_15 Node1_23_16 2.5000000000000004
R_1_23_15_2 Node1_23_15 Node1_24_15 2.5000000000000004
R_1_23_15_3 Node1_23_15 Node2_23_15 10240.000000000002
R_1_23_16_1 Node1_23_16 Node1_23_17 2.5000000000000004
R_1_23_16_2 Node1_23_16 Node1_24_16 2.5000000000000004
R_1_23_16_3 Node1_23_16 Node2_23_16 10240.000000000002
R_1_23_17_1 Node1_23_17 Node1_23_18 2.5000000000000004
R_1_23_17_2 Node1_23_17 Node1_24_17 2.5000000000000004
R_1_23_17_3 Node1_23_17 Node2_23_17 10240.000000000002
R_1_23_18_1 Node1_23_18 Node1_23_19 2.5000000000000004
R_1_23_18_2 Node1_23_18 Node1_24_18 2.5000000000000004
R_1_23_18_3 Node1_23_18 Node2_23_18 10240.000000000002
R_1_23_19_1 Node1_23_19 Node1_23_20 2.5000000000000004
R_1_23_19_2 Node1_23_19 Node1_24_19 2.5000000000000004
R_1_23_19_3 Node1_23_19 Node2_23_19 10240.000000000002
R_1_23_20_1 Node1_23_20 Node1_23_21 2.5000000000000004
R_1_23_20_2 Node1_23_20 Node1_24_20 2.5000000000000004
R_1_23_20_3 Node1_23_20 Node2_23_20 10240.000000000002
R_1_23_21_1 Node1_23_21 Node1_23_22 2.5000000000000004
R_1_23_21_2 Node1_23_21 Node1_24_21 2.5000000000000004
R_1_23_21_3 Node1_23_21 Node2_23_21 10240.000000000002
R_1_23_22_1 Node1_23_22 Node1_23_23 2.5000000000000004
R_1_23_22_2 Node1_23_22 Node1_24_22 2.5000000000000004
R_1_23_22_3 Node1_23_22 Node2_23_22 10240.000000000002
R_1_23_23_1 Node1_23_23 Node1_23_24 2.5000000000000004
R_1_23_23_2 Node1_23_23 Node1_24_23 2.5000000000000004
R_1_23_23_3 Node1_23_23 Node2_23_23 10240.000000000002
R_1_23_24_1 Node1_23_24 Node1_23_25 2.5000000000000004
R_1_23_24_2 Node1_23_24 Node1_24_24 2.5000000000000004
R_1_23_24_3 Node1_23_24 Node2_23_24 10240.000000000002
R_1_23_25_1 Node1_23_25 Node1_23_26 2.5000000000000004
R_1_23_25_2 Node1_23_25 Node1_24_25 2.5000000000000004
R_1_23_25_3 Node1_23_25 Node2_23_25 10240.000000000002
R_1_23_26_1 Node1_23_26 Node1_23_27 2.5000000000000004
R_1_23_26_2 Node1_23_26 Node1_24_26 2.5000000000000004
R_1_23_26_3 Node1_23_26 Node2_23_26 10240.000000000002
R_1_23_27_1 Node1_23_27 Node1_23_28 2.5000000000000004
R_1_23_27_2 Node1_23_27 Node1_24_27 2.5000000000000004
R_1_23_27_3 Node1_23_27 Node2_23_27 10240.000000000002
R_1_23_28_1 Node1_23_28 Node1_23_29 2.5000000000000004
R_1_23_28_2 Node1_23_28 Node1_24_28 2.5000000000000004
R_1_23_28_3 Node1_23_28 Node2_23_28 10240.000000000002
R_1_23_29_1 Node1_23_29 Node1_23_30 2.5000000000000004
R_1_23_29_2 Node1_23_29 Node1_24_29 2.5000000000000004
R_1_23_29_3 Node1_23_29 Node2_23_29 10240.000000000002
R_1_23_30_1 Node1_23_30 Node1_23_31 2.5000000000000004
R_1_23_30_2 Node1_23_30 Node1_24_30 2.5000000000000004
R_1_23_30_3 Node1_23_30 Node2_23_30 10240.000000000002
Rsp_1_23_31_1 Node1_23_31 Node_sp_right 71.54069767441861
R_1_23_31_2 Node1_23_31 Node1_24_31 2.5000000000000004
R_1_23_31_3 Node1_23_31 Node2_23_31 10240.000000000002
R_1_24_0_1 Node1_24_0 Node1_24_1 2.5000000000000004
Rsp_1_24_0_1 Node1_24_0 Node_sp_left 71.54069767441861
R_1_24_0_2 Node1_24_0 Node1_25_0 2.5000000000000004
R_1_24_0_3 Node1_24_0 Node2_24_0 10240.000000000002
R_1_24_1_1 Node1_24_1 Node1_24_2 2.5000000000000004
R_1_24_1_2 Node1_24_1 Node1_25_1 2.5000000000000004
R_1_24_1_3 Node1_24_1 Node2_24_1 10240.000000000002
R_1_24_2_1 Node1_24_2 Node1_24_3 2.5000000000000004
R_1_24_2_2 Node1_24_2 Node1_25_2 2.5000000000000004
R_1_24_2_3 Node1_24_2 Node2_24_2 10240.000000000002
R_1_24_3_1 Node1_24_3 Node1_24_4 2.5000000000000004
R_1_24_3_2 Node1_24_3 Node1_25_3 2.5000000000000004
R_1_24_3_3 Node1_24_3 Node2_24_3 10240.000000000002
R_1_24_4_1 Node1_24_4 Node1_24_5 2.5000000000000004
R_1_24_4_2 Node1_24_4 Node1_25_4 2.5000000000000004
R_1_24_4_3 Node1_24_4 Node2_24_4 10240.000000000002
R_1_24_5_1 Node1_24_5 Node1_24_6 2.5000000000000004
R_1_24_5_2 Node1_24_5 Node1_25_5 2.5000000000000004
R_1_24_5_3 Node1_24_5 Node2_24_5 10240.000000000002
R_1_24_6_1 Node1_24_6 Node1_24_7 2.5000000000000004
R_1_24_6_2 Node1_24_6 Node1_25_6 2.5000000000000004
R_1_24_6_3 Node1_24_6 Node2_24_6 10240.000000000002
R_1_24_7_1 Node1_24_7 Node1_24_8 2.5000000000000004
R_1_24_7_2 Node1_24_7 Node1_25_7 2.5000000000000004
R_1_24_7_3 Node1_24_7 Node2_24_7 10240.000000000002
R_1_24_8_1 Node1_24_8 Node1_24_9 2.5000000000000004
R_1_24_8_2 Node1_24_8 Node1_25_8 2.5000000000000004
R_1_24_8_3 Node1_24_8 Node2_24_8 10240.000000000002
R_1_24_9_1 Node1_24_9 Node1_24_10 2.5000000000000004
R_1_24_9_2 Node1_24_9 Node1_25_9 2.5000000000000004
R_1_24_9_3 Node1_24_9 Node2_24_9 10240.000000000002
R_1_24_10_1 Node1_24_10 Node1_24_11 2.5000000000000004
R_1_24_10_2 Node1_24_10 Node1_25_10 2.5000000000000004
R_1_24_10_3 Node1_24_10 Node2_24_10 10240.000000000002
R_1_24_11_1 Node1_24_11 Node1_24_12 2.5000000000000004
R_1_24_11_2 Node1_24_11 Node1_25_11 2.5000000000000004
R_1_24_11_3 Node1_24_11 Node2_24_11 10240.000000000002
R_1_24_12_1 Node1_24_12 Node1_24_13 2.5000000000000004
R_1_24_12_2 Node1_24_12 Node1_25_12 2.5000000000000004
R_1_24_12_3 Node1_24_12 Node2_24_12 10240.000000000002
R_1_24_13_1 Node1_24_13 Node1_24_14 2.5000000000000004
R_1_24_13_2 Node1_24_13 Node1_25_13 2.5000000000000004
R_1_24_13_3 Node1_24_13 Node2_24_13 10240.000000000002
R_1_24_14_1 Node1_24_14 Node1_24_15 2.5000000000000004
R_1_24_14_2 Node1_24_14 Node1_25_14 2.5000000000000004
R_1_24_14_3 Node1_24_14 Node2_24_14 10240.000000000002
R_1_24_15_1 Node1_24_15 Node1_24_16 2.5000000000000004
R_1_24_15_2 Node1_24_15 Node1_25_15 2.5000000000000004
R_1_24_15_3 Node1_24_15 Node2_24_15 10240.000000000002
R_1_24_16_1 Node1_24_16 Node1_24_17 2.5000000000000004
R_1_24_16_2 Node1_24_16 Node1_25_16 2.5000000000000004
R_1_24_16_3 Node1_24_16 Node2_24_16 10240.000000000002
R_1_24_17_1 Node1_24_17 Node1_24_18 2.5000000000000004
R_1_24_17_2 Node1_24_17 Node1_25_17 2.5000000000000004
R_1_24_17_3 Node1_24_17 Node2_24_17 10240.000000000002
R_1_24_18_1 Node1_24_18 Node1_24_19 2.5000000000000004
R_1_24_18_2 Node1_24_18 Node1_25_18 2.5000000000000004
R_1_24_18_3 Node1_24_18 Node2_24_18 10240.000000000002
R_1_24_19_1 Node1_24_19 Node1_24_20 2.5000000000000004
R_1_24_19_2 Node1_24_19 Node1_25_19 2.5000000000000004
R_1_24_19_3 Node1_24_19 Node2_24_19 10240.000000000002
R_1_24_20_1 Node1_24_20 Node1_24_21 2.5000000000000004
R_1_24_20_2 Node1_24_20 Node1_25_20 2.5000000000000004
R_1_24_20_3 Node1_24_20 Node2_24_20 10240.000000000002
R_1_24_21_1 Node1_24_21 Node1_24_22 2.5000000000000004
R_1_24_21_2 Node1_24_21 Node1_25_21 2.5000000000000004
R_1_24_21_3 Node1_24_21 Node2_24_21 10240.000000000002
R_1_24_22_1 Node1_24_22 Node1_24_23 2.5000000000000004
R_1_24_22_2 Node1_24_22 Node1_25_22 2.5000000000000004
R_1_24_22_3 Node1_24_22 Node2_24_22 10240.000000000002
R_1_24_23_1 Node1_24_23 Node1_24_24 2.5000000000000004
R_1_24_23_2 Node1_24_23 Node1_25_23 2.5000000000000004
R_1_24_23_3 Node1_24_23 Node2_24_23 10240.000000000002
R_1_24_24_1 Node1_24_24 Node1_24_25 2.5000000000000004
R_1_24_24_2 Node1_24_24 Node1_25_24 2.5000000000000004
R_1_24_24_3 Node1_24_24 Node2_24_24 10240.000000000002
R_1_24_25_1 Node1_24_25 Node1_24_26 2.5000000000000004
R_1_24_25_2 Node1_24_25 Node1_25_25 2.5000000000000004
R_1_24_25_3 Node1_24_25 Node2_24_25 10240.000000000002
R_1_24_26_1 Node1_24_26 Node1_24_27 2.5000000000000004
R_1_24_26_2 Node1_24_26 Node1_25_26 2.5000000000000004
R_1_24_26_3 Node1_24_26 Node2_24_26 10240.000000000002
R_1_24_27_1 Node1_24_27 Node1_24_28 2.5000000000000004
R_1_24_27_2 Node1_24_27 Node1_25_27 2.5000000000000004
R_1_24_27_3 Node1_24_27 Node2_24_27 10240.000000000002
R_1_24_28_1 Node1_24_28 Node1_24_29 2.5000000000000004
R_1_24_28_2 Node1_24_28 Node1_25_28 2.5000000000000004
R_1_24_28_3 Node1_24_28 Node2_24_28 10240.000000000002
R_1_24_29_1 Node1_24_29 Node1_24_30 2.5000000000000004
R_1_24_29_2 Node1_24_29 Node1_25_29 2.5000000000000004
R_1_24_29_3 Node1_24_29 Node2_24_29 10240.000000000002
R_1_24_30_1 Node1_24_30 Node1_24_31 2.5000000000000004
R_1_24_30_2 Node1_24_30 Node1_25_30 2.5000000000000004
R_1_24_30_3 Node1_24_30 Node2_24_30 10240.000000000002
Rsp_1_24_31_1 Node1_24_31 Node_sp_right 71.54069767441861
R_1_24_31_2 Node1_24_31 Node1_25_31 2.5000000000000004
R_1_24_31_3 Node1_24_31 Node2_24_31 10240.000000000002
R_1_25_0_1 Node1_25_0 Node1_25_1 2.5000000000000004
Rsp_1_25_0_1 Node1_25_0 Node_sp_left 71.54069767441861
R_1_25_0_2 Node1_25_0 Node1_26_0 2.5000000000000004
R_1_25_0_3 Node1_25_0 Node2_25_0 10240.000000000002
R_1_25_1_1 Node1_25_1 Node1_25_2 2.5000000000000004
R_1_25_1_2 Node1_25_1 Node1_26_1 2.5000000000000004
R_1_25_1_3 Node1_25_1 Node2_25_1 10240.000000000002
R_1_25_2_1 Node1_25_2 Node1_25_3 2.5000000000000004
R_1_25_2_2 Node1_25_2 Node1_26_2 2.5000000000000004
R_1_25_2_3 Node1_25_2 Node2_25_2 10240.000000000002
R_1_25_3_1 Node1_25_3 Node1_25_4 2.5000000000000004
R_1_25_3_2 Node1_25_3 Node1_26_3 2.5000000000000004
R_1_25_3_3 Node1_25_3 Node2_25_3 10240.000000000002
R_1_25_4_1 Node1_25_4 Node1_25_5 2.5000000000000004
R_1_25_4_2 Node1_25_4 Node1_26_4 2.5000000000000004
R_1_25_4_3 Node1_25_4 Node2_25_4 10240.000000000002
R_1_25_5_1 Node1_25_5 Node1_25_6 2.5000000000000004
R_1_25_5_2 Node1_25_5 Node1_26_5 2.5000000000000004
R_1_25_5_3 Node1_25_5 Node2_25_5 10240.000000000002
R_1_25_6_1 Node1_25_6 Node1_25_7 2.5000000000000004
R_1_25_6_2 Node1_25_6 Node1_26_6 2.5000000000000004
R_1_25_6_3 Node1_25_6 Node2_25_6 10240.000000000002
R_1_25_7_1 Node1_25_7 Node1_25_8 2.5000000000000004
R_1_25_7_2 Node1_25_7 Node1_26_7 2.5000000000000004
R_1_25_7_3 Node1_25_7 Node2_25_7 10240.000000000002
R_1_25_8_1 Node1_25_8 Node1_25_9 2.5000000000000004
R_1_25_8_2 Node1_25_8 Node1_26_8 2.5000000000000004
R_1_25_8_3 Node1_25_8 Node2_25_8 10240.000000000002
R_1_25_9_1 Node1_25_9 Node1_25_10 2.5000000000000004
R_1_25_9_2 Node1_25_9 Node1_26_9 2.5000000000000004
R_1_25_9_3 Node1_25_9 Node2_25_9 10240.000000000002
R_1_25_10_1 Node1_25_10 Node1_25_11 2.5000000000000004
R_1_25_10_2 Node1_25_10 Node1_26_10 2.5000000000000004
R_1_25_10_3 Node1_25_10 Node2_25_10 10240.000000000002
R_1_25_11_1 Node1_25_11 Node1_25_12 2.5000000000000004
R_1_25_11_2 Node1_25_11 Node1_26_11 2.5000000000000004
R_1_25_11_3 Node1_25_11 Node2_25_11 10240.000000000002
R_1_25_12_1 Node1_25_12 Node1_25_13 2.5000000000000004
R_1_25_12_2 Node1_25_12 Node1_26_12 2.5000000000000004
R_1_25_12_3 Node1_25_12 Node2_25_12 10240.000000000002
R_1_25_13_1 Node1_25_13 Node1_25_14 2.5000000000000004
R_1_25_13_2 Node1_25_13 Node1_26_13 2.5000000000000004
R_1_25_13_3 Node1_25_13 Node2_25_13 10240.000000000002
R_1_25_14_1 Node1_25_14 Node1_25_15 2.5000000000000004
R_1_25_14_2 Node1_25_14 Node1_26_14 2.5000000000000004
R_1_25_14_3 Node1_25_14 Node2_25_14 10240.000000000002
R_1_25_15_1 Node1_25_15 Node1_25_16 2.5000000000000004
R_1_25_15_2 Node1_25_15 Node1_26_15 2.5000000000000004
R_1_25_15_3 Node1_25_15 Node2_25_15 10240.000000000002
R_1_25_16_1 Node1_25_16 Node1_25_17 2.5000000000000004
R_1_25_16_2 Node1_25_16 Node1_26_16 2.5000000000000004
R_1_25_16_3 Node1_25_16 Node2_25_16 10240.000000000002
R_1_25_17_1 Node1_25_17 Node1_25_18 2.5000000000000004
R_1_25_17_2 Node1_25_17 Node1_26_17 2.5000000000000004
R_1_25_17_3 Node1_25_17 Node2_25_17 10240.000000000002
R_1_25_18_1 Node1_25_18 Node1_25_19 2.5000000000000004
R_1_25_18_2 Node1_25_18 Node1_26_18 2.5000000000000004
R_1_25_18_3 Node1_25_18 Node2_25_18 10240.000000000002
R_1_25_19_1 Node1_25_19 Node1_25_20 2.5000000000000004
R_1_25_19_2 Node1_25_19 Node1_26_19 2.5000000000000004
R_1_25_19_3 Node1_25_19 Node2_25_19 10240.000000000002
R_1_25_20_1 Node1_25_20 Node1_25_21 2.5000000000000004
R_1_25_20_2 Node1_25_20 Node1_26_20 2.5000000000000004
R_1_25_20_3 Node1_25_20 Node2_25_20 10240.000000000002
R_1_25_21_1 Node1_25_21 Node1_25_22 2.5000000000000004
R_1_25_21_2 Node1_25_21 Node1_26_21 2.5000000000000004
R_1_25_21_3 Node1_25_21 Node2_25_21 10240.000000000002
R_1_25_22_1 Node1_25_22 Node1_25_23 2.5000000000000004
R_1_25_22_2 Node1_25_22 Node1_26_22 2.5000000000000004
R_1_25_22_3 Node1_25_22 Node2_25_22 10240.000000000002
R_1_25_23_1 Node1_25_23 Node1_25_24 2.5000000000000004
R_1_25_23_2 Node1_25_23 Node1_26_23 2.5000000000000004
R_1_25_23_3 Node1_25_23 Node2_25_23 10240.000000000002
R_1_25_24_1 Node1_25_24 Node1_25_25 2.5000000000000004
R_1_25_24_2 Node1_25_24 Node1_26_24 2.5000000000000004
R_1_25_24_3 Node1_25_24 Node2_25_24 10240.000000000002
R_1_25_25_1 Node1_25_25 Node1_25_26 2.5000000000000004
R_1_25_25_2 Node1_25_25 Node1_26_25 2.5000000000000004
R_1_25_25_3 Node1_25_25 Node2_25_25 10240.000000000002
R_1_25_26_1 Node1_25_26 Node1_25_27 2.5000000000000004
R_1_25_26_2 Node1_25_26 Node1_26_26 2.5000000000000004
R_1_25_26_3 Node1_25_26 Node2_25_26 10240.000000000002
R_1_25_27_1 Node1_25_27 Node1_25_28 2.5000000000000004
R_1_25_27_2 Node1_25_27 Node1_26_27 2.5000000000000004
R_1_25_27_3 Node1_25_27 Node2_25_27 10240.000000000002
R_1_25_28_1 Node1_25_28 Node1_25_29 2.5000000000000004
R_1_25_28_2 Node1_25_28 Node1_26_28 2.5000000000000004
R_1_25_28_3 Node1_25_28 Node2_25_28 10240.000000000002
R_1_25_29_1 Node1_25_29 Node1_25_30 2.5000000000000004
R_1_25_29_2 Node1_25_29 Node1_26_29 2.5000000000000004
R_1_25_29_3 Node1_25_29 Node2_25_29 10240.000000000002
R_1_25_30_1 Node1_25_30 Node1_25_31 2.5000000000000004
R_1_25_30_2 Node1_25_30 Node1_26_30 2.5000000000000004
R_1_25_30_3 Node1_25_30 Node2_25_30 10240.000000000002
Rsp_1_25_31_1 Node1_25_31 Node_sp_right 71.54069767441861
R_1_25_31_2 Node1_25_31 Node1_26_31 2.5000000000000004
R_1_25_31_3 Node1_25_31 Node2_25_31 10240.000000000002
R_1_26_0_1 Node1_26_0 Node1_26_1 2.5000000000000004
Rsp_1_26_0_1 Node1_26_0 Node_sp_left 71.54069767441861
R_1_26_0_2 Node1_26_0 Node1_27_0 2.5000000000000004
R_1_26_0_3 Node1_26_0 Node2_26_0 10240.000000000002
R_1_26_1_1 Node1_26_1 Node1_26_2 2.5000000000000004
R_1_26_1_2 Node1_26_1 Node1_27_1 2.5000000000000004
R_1_26_1_3 Node1_26_1 Node2_26_1 10240.000000000002
R_1_26_2_1 Node1_26_2 Node1_26_3 2.5000000000000004
R_1_26_2_2 Node1_26_2 Node1_27_2 2.5000000000000004
R_1_26_2_3 Node1_26_2 Node2_26_2 10240.000000000002
R_1_26_3_1 Node1_26_3 Node1_26_4 2.5000000000000004
R_1_26_3_2 Node1_26_3 Node1_27_3 2.5000000000000004
R_1_26_3_3 Node1_26_3 Node2_26_3 10240.000000000002
R_1_26_4_1 Node1_26_4 Node1_26_5 2.5000000000000004
R_1_26_4_2 Node1_26_4 Node1_27_4 2.5000000000000004
R_1_26_4_3 Node1_26_4 Node2_26_4 10240.000000000002
R_1_26_5_1 Node1_26_5 Node1_26_6 2.5000000000000004
R_1_26_5_2 Node1_26_5 Node1_27_5 2.5000000000000004
R_1_26_5_3 Node1_26_5 Node2_26_5 10240.000000000002
R_1_26_6_1 Node1_26_6 Node1_26_7 2.5000000000000004
R_1_26_6_2 Node1_26_6 Node1_27_6 2.5000000000000004
R_1_26_6_3 Node1_26_6 Node2_26_6 10240.000000000002
R_1_26_7_1 Node1_26_7 Node1_26_8 2.5000000000000004
R_1_26_7_2 Node1_26_7 Node1_27_7 2.5000000000000004
R_1_26_7_3 Node1_26_7 Node2_26_7 10240.000000000002
R_1_26_8_1 Node1_26_8 Node1_26_9 2.5000000000000004
R_1_26_8_2 Node1_26_8 Node1_27_8 2.5000000000000004
R_1_26_8_3 Node1_26_8 Node2_26_8 10240.000000000002
R_1_26_9_1 Node1_26_9 Node1_26_10 2.5000000000000004
R_1_26_9_2 Node1_26_9 Node1_27_9 2.5000000000000004
R_1_26_9_3 Node1_26_9 Node2_26_9 10240.000000000002
R_1_26_10_1 Node1_26_10 Node1_26_11 2.5000000000000004
R_1_26_10_2 Node1_26_10 Node1_27_10 2.5000000000000004
R_1_26_10_3 Node1_26_10 Node2_26_10 10240.000000000002
R_1_26_11_1 Node1_26_11 Node1_26_12 2.5000000000000004
R_1_26_11_2 Node1_26_11 Node1_27_11 2.5000000000000004
R_1_26_11_3 Node1_26_11 Node2_26_11 10240.000000000002
R_1_26_12_1 Node1_26_12 Node1_26_13 2.5000000000000004
R_1_26_12_2 Node1_26_12 Node1_27_12 2.5000000000000004
R_1_26_12_3 Node1_26_12 Node2_26_12 10240.000000000002
R_1_26_13_1 Node1_26_13 Node1_26_14 2.5000000000000004
R_1_26_13_2 Node1_26_13 Node1_27_13 2.5000000000000004
R_1_26_13_3 Node1_26_13 Node2_26_13 10240.000000000002
R_1_26_14_1 Node1_26_14 Node1_26_15 2.5000000000000004
R_1_26_14_2 Node1_26_14 Node1_27_14 2.5000000000000004
R_1_26_14_3 Node1_26_14 Node2_26_14 10240.000000000002
R_1_26_15_1 Node1_26_15 Node1_26_16 2.5000000000000004
R_1_26_15_2 Node1_26_15 Node1_27_15 2.5000000000000004
R_1_26_15_3 Node1_26_15 Node2_26_15 10240.000000000002
R_1_26_16_1 Node1_26_16 Node1_26_17 2.5000000000000004
R_1_26_16_2 Node1_26_16 Node1_27_16 2.5000000000000004
R_1_26_16_3 Node1_26_16 Node2_26_16 10240.000000000002
R_1_26_17_1 Node1_26_17 Node1_26_18 2.5000000000000004
R_1_26_17_2 Node1_26_17 Node1_27_17 2.5000000000000004
R_1_26_17_3 Node1_26_17 Node2_26_17 10240.000000000002
R_1_26_18_1 Node1_26_18 Node1_26_19 2.5000000000000004
R_1_26_18_2 Node1_26_18 Node1_27_18 2.5000000000000004
R_1_26_18_3 Node1_26_18 Node2_26_18 10240.000000000002
R_1_26_19_1 Node1_26_19 Node1_26_20 2.5000000000000004
R_1_26_19_2 Node1_26_19 Node1_27_19 2.5000000000000004
R_1_26_19_3 Node1_26_19 Node2_26_19 10240.000000000002
R_1_26_20_1 Node1_26_20 Node1_26_21 2.5000000000000004
R_1_26_20_2 Node1_26_20 Node1_27_20 2.5000000000000004
R_1_26_20_3 Node1_26_20 Node2_26_20 10240.000000000002
R_1_26_21_1 Node1_26_21 Node1_26_22 2.5000000000000004
R_1_26_21_2 Node1_26_21 Node1_27_21 2.5000000000000004
R_1_26_21_3 Node1_26_21 Node2_26_21 10240.000000000002
R_1_26_22_1 Node1_26_22 Node1_26_23 2.5000000000000004
R_1_26_22_2 Node1_26_22 Node1_27_22 2.5000000000000004
R_1_26_22_3 Node1_26_22 Node2_26_22 10240.000000000002
R_1_26_23_1 Node1_26_23 Node1_26_24 2.5000000000000004
R_1_26_23_2 Node1_26_23 Node1_27_23 2.5000000000000004
R_1_26_23_3 Node1_26_23 Node2_26_23 10240.000000000002
R_1_26_24_1 Node1_26_24 Node1_26_25 2.5000000000000004
R_1_26_24_2 Node1_26_24 Node1_27_24 2.5000000000000004
R_1_26_24_3 Node1_26_24 Node2_26_24 10240.000000000002
R_1_26_25_1 Node1_26_25 Node1_26_26 2.5000000000000004
R_1_26_25_2 Node1_26_25 Node1_27_25 2.5000000000000004
R_1_26_25_3 Node1_26_25 Node2_26_25 10240.000000000002
R_1_26_26_1 Node1_26_26 Node1_26_27 2.5000000000000004
R_1_26_26_2 Node1_26_26 Node1_27_26 2.5000000000000004
R_1_26_26_3 Node1_26_26 Node2_26_26 10240.000000000002
R_1_26_27_1 Node1_26_27 Node1_26_28 2.5000000000000004
R_1_26_27_2 Node1_26_27 Node1_27_27 2.5000000000000004
R_1_26_27_3 Node1_26_27 Node2_26_27 10240.000000000002
R_1_26_28_1 Node1_26_28 Node1_26_29 2.5000000000000004
R_1_26_28_2 Node1_26_28 Node1_27_28 2.5000000000000004
R_1_26_28_3 Node1_26_28 Node2_26_28 10240.000000000002
R_1_26_29_1 Node1_26_29 Node1_26_30 2.5000000000000004
R_1_26_29_2 Node1_26_29 Node1_27_29 2.5000000000000004
R_1_26_29_3 Node1_26_29 Node2_26_29 10240.000000000002
R_1_26_30_1 Node1_26_30 Node1_26_31 2.5000000000000004
R_1_26_30_2 Node1_26_30 Node1_27_30 2.5000000000000004
R_1_26_30_3 Node1_26_30 Node2_26_30 10240.000000000002
Rsp_1_26_31_1 Node1_26_31 Node_sp_right 71.54069767441861
R_1_26_31_2 Node1_26_31 Node1_27_31 2.5000000000000004
R_1_26_31_3 Node1_26_31 Node2_26_31 10240.000000000002
R_1_27_0_1 Node1_27_0 Node1_27_1 2.5000000000000004
Rsp_1_27_0_1 Node1_27_0 Node_sp_left 71.54069767441861
R_1_27_0_2 Node1_27_0 Node1_28_0 2.5000000000000004
R_1_27_0_3 Node1_27_0 Node2_27_0 10240.000000000002
R_1_27_1_1 Node1_27_1 Node1_27_2 2.5000000000000004
R_1_27_1_2 Node1_27_1 Node1_28_1 2.5000000000000004
R_1_27_1_3 Node1_27_1 Node2_27_1 10240.000000000002
R_1_27_2_1 Node1_27_2 Node1_27_3 2.5000000000000004
R_1_27_2_2 Node1_27_2 Node1_28_2 2.5000000000000004
R_1_27_2_3 Node1_27_2 Node2_27_2 10240.000000000002
R_1_27_3_1 Node1_27_3 Node1_27_4 2.5000000000000004
R_1_27_3_2 Node1_27_3 Node1_28_3 2.5000000000000004
R_1_27_3_3 Node1_27_3 Node2_27_3 10240.000000000002
R_1_27_4_1 Node1_27_4 Node1_27_5 2.5000000000000004
R_1_27_4_2 Node1_27_4 Node1_28_4 2.5000000000000004
R_1_27_4_3 Node1_27_4 Node2_27_4 10240.000000000002
R_1_27_5_1 Node1_27_5 Node1_27_6 2.5000000000000004
R_1_27_5_2 Node1_27_5 Node1_28_5 2.5000000000000004
R_1_27_5_3 Node1_27_5 Node2_27_5 10240.000000000002
R_1_27_6_1 Node1_27_6 Node1_27_7 2.5000000000000004
R_1_27_6_2 Node1_27_6 Node1_28_6 2.5000000000000004
R_1_27_6_3 Node1_27_6 Node2_27_6 10240.000000000002
R_1_27_7_1 Node1_27_7 Node1_27_8 2.5000000000000004
R_1_27_7_2 Node1_27_7 Node1_28_7 2.5000000000000004
R_1_27_7_3 Node1_27_7 Node2_27_7 10240.000000000002
R_1_27_8_1 Node1_27_8 Node1_27_9 2.5000000000000004
R_1_27_8_2 Node1_27_8 Node1_28_8 2.5000000000000004
R_1_27_8_3 Node1_27_8 Node2_27_8 10240.000000000002
R_1_27_9_1 Node1_27_9 Node1_27_10 2.5000000000000004
R_1_27_9_2 Node1_27_9 Node1_28_9 2.5000000000000004
R_1_27_9_3 Node1_27_9 Node2_27_9 10240.000000000002
R_1_27_10_1 Node1_27_10 Node1_27_11 2.5000000000000004
R_1_27_10_2 Node1_27_10 Node1_28_10 2.5000000000000004
R_1_27_10_3 Node1_27_10 Node2_27_10 10240.000000000002
R_1_27_11_1 Node1_27_11 Node1_27_12 2.5000000000000004
R_1_27_11_2 Node1_27_11 Node1_28_11 2.5000000000000004
R_1_27_11_3 Node1_27_11 Node2_27_11 10240.000000000002
R_1_27_12_1 Node1_27_12 Node1_27_13 2.5000000000000004
R_1_27_12_2 Node1_27_12 Node1_28_12 2.5000000000000004
R_1_27_12_3 Node1_27_12 Node2_27_12 10240.000000000002
R_1_27_13_1 Node1_27_13 Node1_27_14 2.5000000000000004
R_1_27_13_2 Node1_27_13 Node1_28_13 2.5000000000000004
R_1_27_13_3 Node1_27_13 Node2_27_13 10240.000000000002
R_1_27_14_1 Node1_27_14 Node1_27_15 2.5000000000000004
R_1_27_14_2 Node1_27_14 Node1_28_14 2.5000000000000004
R_1_27_14_3 Node1_27_14 Node2_27_14 10240.000000000002
R_1_27_15_1 Node1_27_15 Node1_27_16 2.5000000000000004
R_1_27_15_2 Node1_27_15 Node1_28_15 2.5000000000000004
R_1_27_15_3 Node1_27_15 Node2_27_15 10240.000000000002
R_1_27_16_1 Node1_27_16 Node1_27_17 2.5000000000000004
R_1_27_16_2 Node1_27_16 Node1_28_16 2.5000000000000004
R_1_27_16_3 Node1_27_16 Node2_27_16 10240.000000000002
R_1_27_17_1 Node1_27_17 Node1_27_18 2.5000000000000004
R_1_27_17_2 Node1_27_17 Node1_28_17 2.5000000000000004
R_1_27_17_3 Node1_27_17 Node2_27_17 10240.000000000002
R_1_27_18_1 Node1_27_18 Node1_27_19 2.5000000000000004
R_1_27_18_2 Node1_27_18 Node1_28_18 2.5000000000000004
R_1_27_18_3 Node1_27_18 Node2_27_18 10240.000000000002
R_1_27_19_1 Node1_27_19 Node1_27_20 2.5000000000000004
R_1_27_19_2 Node1_27_19 Node1_28_19 2.5000000000000004
R_1_27_19_3 Node1_27_19 Node2_27_19 10240.000000000002
R_1_27_20_1 Node1_27_20 Node1_27_21 2.5000000000000004
R_1_27_20_2 Node1_27_20 Node1_28_20 2.5000000000000004
R_1_27_20_3 Node1_27_20 Node2_27_20 10240.000000000002
R_1_27_21_1 Node1_27_21 Node1_27_22 2.5000000000000004
R_1_27_21_2 Node1_27_21 Node1_28_21 2.5000000000000004
R_1_27_21_3 Node1_27_21 Node2_27_21 10240.000000000002
R_1_27_22_1 Node1_27_22 Node1_27_23 2.5000000000000004
R_1_27_22_2 Node1_27_22 Node1_28_22 2.5000000000000004
R_1_27_22_3 Node1_27_22 Node2_27_22 10240.000000000002
R_1_27_23_1 Node1_27_23 Node1_27_24 2.5000000000000004
R_1_27_23_2 Node1_27_23 Node1_28_23 2.5000000000000004
R_1_27_23_3 Node1_27_23 Node2_27_23 10240.000000000002
R_1_27_24_1 Node1_27_24 Node1_27_25 2.5000000000000004
R_1_27_24_2 Node1_27_24 Node1_28_24 2.5000000000000004
R_1_27_24_3 Node1_27_24 Node2_27_24 10240.000000000002
R_1_27_25_1 Node1_27_25 Node1_27_26 2.5000000000000004
R_1_27_25_2 Node1_27_25 Node1_28_25 2.5000000000000004
R_1_27_25_3 Node1_27_25 Node2_27_25 10240.000000000002
R_1_27_26_1 Node1_27_26 Node1_27_27 2.5000000000000004
R_1_27_26_2 Node1_27_26 Node1_28_26 2.5000000000000004
R_1_27_26_3 Node1_27_26 Node2_27_26 10240.000000000002
R_1_27_27_1 Node1_27_27 Node1_27_28 2.5000000000000004
R_1_27_27_2 Node1_27_27 Node1_28_27 2.5000000000000004
R_1_27_27_3 Node1_27_27 Node2_27_27 10240.000000000002
R_1_27_28_1 Node1_27_28 Node1_27_29 2.5000000000000004
R_1_27_28_2 Node1_27_28 Node1_28_28 2.5000000000000004
R_1_27_28_3 Node1_27_28 Node2_27_28 10240.000000000002
R_1_27_29_1 Node1_27_29 Node1_27_30 2.5000000000000004
R_1_27_29_2 Node1_27_29 Node1_28_29 2.5000000000000004
R_1_27_29_3 Node1_27_29 Node2_27_29 10240.000000000002
R_1_27_30_1 Node1_27_30 Node1_27_31 2.5000000000000004
R_1_27_30_2 Node1_27_30 Node1_28_30 2.5000000000000004
R_1_27_30_3 Node1_27_30 Node2_27_30 10240.000000000002
Rsp_1_27_31_1 Node1_27_31 Node_sp_right 71.54069767441861
R_1_27_31_2 Node1_27_31 Node1_28_31 2.5000000000000004
R_1_27_31_3 Node1_27_31 Node2_27_31 10240.000000000002
R_1_28_0_1 Node1_28_0 Node1_28_1 2.5000000000000004
Rsp_1_28_0_1 Node1_28_0 Node_sp_left 71.54069767441861
R_1_28_0_2 Node1_28_0 Node1_29_0 2.5000000000000004
R_1_28_0_3 Node1_28_0 Node2_28_0 10240.000000000002
R_1_28_1_1 Node1_28_1 Node1_28_2 2.5000000000000004
R_1_28_1_2 Node1_28_1 Node1_29_1 2.5000000000000004
R_1_28_1_3 Node1_28_1 Node2_28_1 10240.000000000002
R_1_28_2_1 Node1_28_2 Node1_28_3 2.5000000000000004
R_1_28_2_2 Node1_28_2 Node1_29_2 2.5000000000000004
R_1_28_2_3 Node1_28_2 Node2_28_2 10240.000000000002
R_1_28_3_1 Node1_28_3 Node1_28_4 2.5000000000000004
R_1_28_3_2 Node1_28_3 Node1_29_3 2.5000000000000004
R_1_28_3_3 Node1_28_3 Node2_28_3 10240.000000000002
R_1_28_4_1 Node1_28_4 Node1_28_5 2.5000000000000004
R_1_28_4_2 Node1_28_4 Node1_29_4 2.5000000000000004
R_1_28_4_3 Node1_28_4 Node2_28_4 10240.000000000002
R_1_28_5_1 Node1_28_5 Node1_28_6 2.5000000000000004
R_1_28_5_2 Node1_28_5 Node1_29_5 2.5000000000000004
R_1_28_5_3 Node1_28_5 Node2_28_5 10240.000000000002
R_1_28_6_1 Node1_28_6 Node1_28_7 2.5000000000000004
R_1_28_6_2 Node1_28_6 Node1_29_6 2.5000000000000004
R_1_28_6_3 Node1_28_6 Node2_28_6 10240.000000000002
R_1_28_7_1 Node1_28_7 Node1_28_8 2.5000000000000004
R_1_28_7_2 Node1_28_7 Node1_29_7 2.5000000000000004
R_1_28_7_3 Node1_28_7 Node2_28_7 10240.000000000002
R_1_28_8_1 Node1_28_8 Node1_28_9 2.5000000000000004
R_1_28_8_2 Node1_28_8 Node1_29_8 2.5000000000000004
R_1_28_8_3 Node1_28_8 Node2_28_8 10240.000000000002
R_1_28_9_1 Node1_28_9 Node1_28_10 2.5000000000000004
R_1_28_9_2 Node1_28_9 Node1_29_9 2.5000000000000004
R_1_28_9_3 Node1_28_9 Node2_28_9 10240.000000000002
R_1_28_10_1 Node1_28_10 Node1_28_11 2.5000000000000004
R_1_28_10_2 Node1_28_10 Node1_29_10 2.5000000000000004
R_1_28_10_3 Node1_28_10 Node2_28_10 10240.000000000002
R_1_28_11_1 Node1_28_11 Node1_28_12 2.5000000000000004
R_1_28_11_2 Node1_28_11 Node1_29_11 2.5000000000000004
R_1_28_11_3 Node1_28_11 Node2_28_11 10240.000000000002
R_1_28_12_1 Node1_28_12 Node1_28_13 2.5000000000000004
R_1_28_12_2 Node1_28_12 Node1_29_12 2.5000000000000004
R_1_28_12_3 Node1_28_12 Node2_28_12 10240.000000000002
R_1_28_13_1 Node1_28_13 Node1_28_14 2.5000000000000004
R_1_28_13_2 Node1_28_13 Node1_29_13 2.5000000000000004
R_1_28_13_3 Node1_28_13 Node2_28_13 10240.000000000002
R_1_28_14_1 Node1_28_14 Node1_28_15 2.5000000000000004
R_1_28_14_2 Node1_28_14 Node1_29_14 2.5000000000000004
R_1_28_14_3 Node1_28_14 Node2_28_14 10240.000000000002
R_1_28_15_1 Node1_28_15 Node1_28_16 2.5000000000000004
R_1_28_15_2 Node1_28_15 Node1_29_15 2.5000000000000004
R_1_28_15_3 Node1_28_15 Node2_28_15 10240.000000000002
R_1_28_16_1 Node1_28_16 Node1_28_17 2.5000000000000004
R_1_28_16_2 Node1_28_16 Node1_29_16 2.5000000000000004
R_1_28_16_3 Node1_28_16 Node2_28_16 10240.000000000002
R_1_28_17_1 Node1_28_17 Node1_28_18 2.5000000000000004
R_1_28_17_2 Node1_28_17 Node1_29_17 2.5000000000000004
R_1_28_17_3 Node1_28_17 Node2_28_17 10240.000000000002
R_1_28_18_1 Node1_28_18 Node1_28_19 2.5000000000000004
R_1_28_18_2 Node1_28_18 Node1_29_18 2.5000000000000004
R_1_28_18_3 Node1_28_18 Node2_28_18 10240.000000000002
R_1_28_19_1 Node1_28_19 Node1_28_20 2.5000000000000004
R_1_28_19_2 Node1_28_19 Node1_29_19 2.5000000000000004
R_1_28_19_3 Node1_28_19 Node2_28_19 10240.000000000002
R_1_28_20_1 Node1_28_20 Node1_28_21 2.5000000000000004
R_1_28_20_2 Node1_28_20 Node1_29_20 2.5000000000000004
R_1_28_20_3 Node1_28_20 Node2_28_20 10240.000000000002
R_1_28_21_1 Node1_28_21 Node1_28_22 2.5000000000000004
R_1_28_21_2 Node1_28_21 Node1_29_21 2.5000000000000004
R_1_28_21_3 Node1_28_21 Node2_28_21 10240.000000000002
R_1_28_22_1 Node1_28_22 Node1_28_23 2.5000000000000004
R_1_28_22_2 Node1_28_22 Node1_29_22 2.5000000000000004
R_1_28_22_3 Node1_28_22 Node2_28_22 10240.000000000002
R_1_28_23_1 Node1_28_23 Node1_28_24 2.5000000000000004
R_1_28_23_2 Node1_28_23 Node1_29_23 2.5000000000000004
R_1_28_23_3 Node1_28_23 Node2_28_23 10240.000000000002
R_1_28_24_1 Node1_28_24 Node1_28_25 2.5000000000000004
R_1_28_24_2 Node1_28_24 Node1_29_24 2.5000000000000004
R_1_28_24_3 Node1_28_24 Node2_28_24 10240.000000000002
R_1_28_25_1 Node1_28_25 Node1_28_26 2.5000000000000004
R_1_28_25_2 Node1_28_25 Node1_29_25 2.5000000000000004
R_1_28_25_3 Node1_28_25 Node2_28_25 10240.000000000002
R_1_28_26_1 Node1_28_26 Node1_28_27 2.5000000000000004
R_1_28_26_2 Node1_28_26 Node1_29_26 2.5000000000000004
R_1_28_26_3 Node1_28_26 Node2_28_26 10240.000000000002
R_1_28_27_1 Node1_28_27 Node1_28_28 2.5000000000000004
R_1_28_27_2 Node1_28_27 Node1_29_27 2.5000000000000004
R_1_28_27_3 Node1_28_27 Node2_28_27 10240.000000000002
R_1_28_28_1 Node1_28_28 Node1_28_29 2.5000000000000004
R_1_28_28_2 Node1_28_28 Node1_29_28 2.5000000000000004
R_1_28_28_3 Node1_28_28 Node2_28_28 10240.000000000002
R_1_28_29_1 Node1_28_29 Node1_28_30 2.5000000000000004
R_1_28_29_2 Node1_28_29 Node1_29_29 2.5000000000000004
R_1_28_29_3 Node1_28_29 Node2_28_29 10240.000000000002
R_1_28_30_1 Node1_28_30 Node1_28_31 2.5000000000000004
R_1_28_30_2 Node1_28_30 Node1_29_30 2.5000000000000004
R_1_28_30_3 Node1_28_30 Node2_28_30 10240.000000000002
Rsp_1_28_31_1 Node1_28_31 Node_sp_right 71.54069767441861
R_1_28_31_2 Node1_28_31 Node1_29_31 2.5000000000000004
R_1_28_31_3 Node1_28_31 Node2_28_31 10240.000000000002
R_1_29_0_1 Node1_29_0 Node1_29_1 2.5000000000000004
Rsp_1_29_0_1 Node1_29_0 Node_sp_left 71.54069767441861
R_1_29_0_2 Node1_29_0 Node1_30_0 2.5000000000000004
R_1_29_0_3 Node1_29_0 Node2_29_0 10240.000000000002
R_1_29_1_1 Node1_29_1 Node1_29_2 2.5000000000000004
R_1_29_1_2 Node1_29_1 Node1_30_1 2.5000000000000004
R_1_29_1_3 Node1_29_1 Node2_29_1 10240.000000000002
R_1_29_2_1 Node1_29_2 Node1_29_3 2.5000000000000004
R_1_29_2_2 Node1_29_2 Node1_30_2 2.5000000000000004
R_1_29_2_3 Node1_29_2 Node2_29_2 10240.000000000002
R_1_29_3_1 Node1_29_3 Node1_29_4 2.5000000000000004
R_1_29_3_2 Node1_29_3 Node1_30_3 2.5000000000000004
R_1_29_3_3 Node1_29_3 Node2_29_3 10240.000000000002
R_1_29_4_1 Node1_29_4 Node1_29_5 2.5000000000000004
R_1_29_4_2 Node1_29_4 Node1_30_4 2.5000000000000004
R_1_29_4_3 Node1_29_4 Node2_29_4 10240.000000000002
R_1_29_5_1 Node1_29_5 Node1_29_6 2.5000000000000004
R_1_29_5_2 Node1_29_5 Node1_30_5 2.5000000000000004
R_1_29_5_3 Node1_29_5 Node2_29_5 10240.000000000002
R_1_29_6_1 Node1_29_6 Node1_29_7 2.5000000000000004
R_1_29_6_2 Node1_29_6 Node1_30_6 2.5000000000000004
R_1_29_6_3 Node1_29_6 Node2_29_6 10240.000000000002
R_1_29_7_1 Node1_29_7 Node1_29_8 2.5000000000000004
R_1_29_7_2 Node1_29_7 Node1_30_7 2.5000000000000004
R_1_29_7_3 Node1_29_7 Node2_29_7 10240.000000000002
R_1_29_8_1 Node1_29_8 Node1_29_9 2.5000000000000004
R_1_29_8_2 Node1_29_8 Node1_30_8 2.5000000000000004
R_1_29_8_3 Node1_29_8 Node2_29_8 10240.000000000002
R_1_29_9_1 Node1_29_9 Node1_29_10 2.5000000000000004
R_1_29_9_2 Node1_29_9 Node1_30_9 2.5000000000000004
R_1_29_9_3 Node1_29_9 Node2_29_9 10240.000000000002
R_1_29_10_1 Node1_29_10 Node1_29_11 2.5000000000000004
R_1_29_10_2 Node1_29_10 Node1_30_10 2.5000000000000004
R_1_29_10_3 Node1_29_10 Node2_29_10 10240.000000000002
R_1_29_11_1 Node1_29_11 Node1_29_12 2.5000000000000004
R_1_29_11_2 Node1_29_11 Node1_30_11 2.5000000000000004
R_1_29_11_3 Node1_29_11 Node2_29_11 10240.000000000002
R_1_29_12_1 Node1_29_12 Node1_29_13 2.5000000000000004
R_1_29_12_2 Node1_29_12 Node1_30_12 2.5000000000000004
R_1_29_12_3 Node1_29_12 Node2_29_12 10240.000000000002
R_1_29_13_1 Node1_29_13 Node1_29_14 2.5000000000000004
R_1_29_13_2 Node1_29_13 Node1_30_13 2.5000000000000004
R_1_29_13_3 Node1_29_13 Node2_29_13 10240.000000000002
R_1_29_14_1 Node1_29_14 Node1_29_15 2.5000000000000004
R_1_29_14_2 Node1_29_14 Node1_30_14 2.5000000000000004
R_1_29_14_3 Node1_29_14 Node2_29_14 10240.000000000002
R_1_29_15_1 Node1_29_15 Node1_29_16 2.5000000000000004
R_1_29_15_2 Node1_29_15 Node1_30_15 2.5000000000000004
R_1_29_15_3 Node1_29_15 Node2_29_15 10240.000000000002
R_1_29_16_1 Node1_29_16 Node1_29_17 2.5000000000000004
R_1_29_16_2 Node1_29_16 Node1_30_16 2.5000000000000004
R_1_29_16_3 Node1_29_16 Node2_29_16 10240.000000000002
R_1_29_17_1 Node1_29_17 Node1_29_18 2.5000000000000004
R_1_29_17_2 Node1_29_17 Node1_30_17 2.5000000000000004
R_1_29_17_3 Node1_29_17 Node2_29_17 10240.000000000002
R_1_29_18_1 Node1_29_18 Node1_29_19 2.5000000000000004
R_1_29_18_2 Node1_29_18 Node1_30_18 2.5000000000000004
R_1_29_18_3 Node1_29_18 Node2_29_18 10240.000000000002
R_1_29_19_1 Node1_29_19 Node1_29_20 2.5000000000000004
R_1_29_19_2 Node1_29_19 Node1_30_19 2.5000000000000004
R_1_29_19_3 Node1_29_19 Node2_29_19 10240.000000000002
R_1_29_20_1 Node1_29_20 Node1_29_21 2.5000000000000004
R_1_29_20_2 Node1_29_20 Node1_30_20 2.5000000000000004
R_1_29_20_3 Node1_29_20 Node2_29_20 10240.000000000002
R_1_29_21_1 Node1_29_21 Node1_29_22 2.5000000000000004
R_1_29_21_2 Node1_29_21 Node1_30_21 2.5000000000000004
R_1_29_21_3 Node1_29_21 Node2_29_21 10240.000000000002
R_1_29_22_1 Node1_29_22 Node1_29_23 2.5000000000000004
R_1_29_22_2 Node1_29_22 Node1_30_22 2.5000000000000004
R_1_29_22_3 Node1_29_22 Node2_29_22 10240.000000000002
R_1_29_23_1 Node1_29_23 Node1_29_24 2.5000000000000004
R_1_29_23_2 Node1_29_23 Node1_30_23 2.5000000000000004
R_1_29_23_3 Node1_29_23 Node2_29_23 10240.000000000002
R_1_29_24_1 Node1_29_24 Node1_29_25 2.5000000000000004
R_1_29_24_2 Node1_29_24 Node1_30_24 2.5000000000000004
R_1_29_24_3 Node1_29_24 Node2_29_24 10240.000000000002
R_1_29_25_1 Node1_29_25 Node1_29_26 2.5000000000000004
R_1_29_25_2 Node1_29_25 Node1_30_25 2.5000000000000004
R_1_29_25_3 Node1_29_25 Node2_29_25 10240.000000000002
R_1_29_26_1 Node1_29_26 Node1_29_27 2.5000000000000004
R_1_29_26_2 Node1_29_26 Node1_30_26 2.5000000000000004
R_1_29_26_3 Node1_29_26 Node2_29_26 10240.000000000002
R_1_29_27_1 Node1_29_27 Node1_29_28 2.5000000000000004
R_1_29_27_2 Node1_29_27 Node1_30_27 2.5000000000000004
R_1_29_27_3 Node1_29_27 Node2_29_27 10240.000000000002
R_1_29_28_1 Node1_29_28 Node1_29_29 2.5000000000000004
R_1_29_28_2 Node1_29_28 Node1_30_28 2.5000000000000004
R_1_29_28_3 Node1_29_28 Node2_29_28 10240.000000000002
R_1_29_29_1 Node1_29_29 Node1_29_30 2.5000000000000004
R_1_29_29_2 Node1_29_29 Node1_30_29 2.5000000000000004
R_1_29_29_3 Node1_29_29 Node2_29_29 10240.000000000002
R_1_29_30_1 Node1_29_30 Node1_29_31 2.5000000000000004
R_1_29_30_2 Node1_29_30 Node1_30_30 2.5000000000000004
R_1_29_30_3 Node1_29_30 Node2_29_30 10240.000000000002
Rsp_1_29_31_1 Node1_29_31 Node_sp_right 71.54069767441861
R_1_29_31_2 Node1_29_31 Node1_30_31 2.5000000000000004
R_1_29_31_3 Node1_29_31 Node2_29_31 10240.000000000002
R_1_30_0_1 Node1_30_0 Node1_30_1 2.5000000000000004
Rsp_1_30_0_1 Node1_30_0 Node_sp_left 71.54069767441861
R_1_30_0_2 Node1_30_0 Node1_31_0 2.5000000000000004
R_1_30_0_3 Node1_30_0 Node2_30_0 10240.000000000002
R_1_30_1_1 Node1_30_1 Node1_30_2 2.5000000000000004
R_1_30_1_2 Node1_30_1 Node1_31_1 2.5000000000000004
R_1_30_1_3 Node1_30_1 Node2_30_1 10240.000000000002
R_1_30_2_1 Node1_30_2 Node1_30_3 2.5000000000000004
R_1_30_2_2 Node1_30_2 Node1_31_2 2.5000000000000004
R_1_30_2_3 Node1_30_2 Node2_30_2 10240.000000000002
R_1_30_3_1 Node1_30_3 Node1_30_4 2.5000000000000004
R_1_30_3_2 Node1_30_3 Node1_31_3 2.5000000000000004
R_1_30_3_3 Node1_30_3 Node2_30_3 10240.000000000002
R_1_30_4_1 Node1_30_4 Node1_30_5 2.5000000000000004
R_1_30_4_2 Node1_30_4 Node1_31_4 2.5000000000000004
R_1_30_4_3 Node1_30_4 Node2_30_4 10240.000000000002
R_1_30_5_1 Node1_30_5 Node1_30_6 2.5000000000000004
R_1_30_5_2 Node1_30_5 Node1_31_5 2.5000000000000004
R_1_30_5_3 Node1_30_5 Node2_30_5 10240.000000000002
R_1_30_6_1 Node1_30_6 Node1_30_7 2.5000000000000004
R_1_30_6_2 Node1_30_6 Node1_31_6 2.5000000000000004
R_1_30_6_3 Node1_30_6 Node2_30_6 10240.000000000002
R_1_30_7_1 Node1_30_7 Node1_30_8 2.5000000000000004
R_1_30_7_2 Node1_30_7 Node1_31_7 2.5000000000000004
R_1_30_7_3 Node1_30_7 Node2_30_7 10240.000000000002
R_1_30_8_1 Node1_30_8 Node1_30_9 2.5000000000000004
R_1_30_8_2 Node1_30_8 Node1_31_8 2.5000000000000004
R_1_30_8_3 Node1_30_8 Node2_30_8 10240.000000000002
R_1_30_9_1 Node1_30_9 Node1_30_10 2.5000000000000004
R_1_30_9_2 Node1_30_9 Node1_31_9 2.5000000000000004
R_1_30_9_3 Node1_30_9 Node2_30_9 10240.000000000002
R_1_30_10_1 Node1_30_10 Node1_30_11 2.5000000000000004
R_1_30_10_2 Node1_30_10 Node1_31_10 2.5000000000000004
R_1_30_10_3 Node1_30_10 Node2_30_10 10240.000000000002
R_1_30_11_1 Node1_30_11 Node1_30_12 2.5000000000000004
R_1_30_11_2 Node1_30_11 Node1_31_11 2.5000000000000004
R_1_30_11_3 Node1_30_11 Node2_30_11 10240.000000000002
R_1_30_12_1 Node1_30_12 Node1_30_13 2.5000000000000004
R_1_30_12_2 Node1_30_12 Node1_31_12 2.5000000000000004
R_1_30_12_3 Node1_30_12 Node2_30_12 10240.000000000002
R_1_30_13_1 Node1_30_13 Node1_30_14 2.5000000000000004
R_1_30_13_2 Node1_30_13 Node1_31_13 2.5000000000000004
R_1_30_13_3 Node1_30_13 Node2_30_13 10240.000000000002
R_1_30_14_1 Node1_30_14 Node1_30_15 2.5000000000000004
R_1_30_14_2 Node1_30_14 Node1_31_14 2.5000000000000004
R_1_30_14_3 Node1_30_14 Node2_30_14 10240.000000000002
R_1_30_15_1 Node1_30_15 Node1_30_16 2.5000000000000004
R_1_30_15_2 Node1_30_15 Node1_31_15 2.5000000000000004
R_1_30_15_3 Node1_30_15 Node2_30_15 10240.000000000002
R_1_30_16_1 Node1_30_16 Node1_30_17 2.5000000000000004
R_1_30_16_2 Node1_30_16 Node1_31_16 2.5000000000000004
R_1_30_16_3 Node1_30_16 Node2_30_16 10240.000000000002
R_1_30_17_1 Node1_30_17 Node1_30_18 2.5000000000000004
R_1_30_17_2 Node1_30_17 Node1_31_17 2.5000000000000004
R_1_30_17_3 Node1_30_17 Node2_30_17 10240.000000000002
R_1_30_18_1 Node1_30_18 Node1_30_19 2.5000000000000004
R_1_30_18_2 Node1_30_18 Node1_31_18 2.5000000000000004
R_1_30_18_3 Node1_30_18 Node2_30_18 10240.000000000002
R_1_30_19_1 Node1_30_19 Node1_30_20 2.5000000000000004
R_1_30_19_2 Node1_30_19 Node1_31_19 2.5000000000000004
R_1_30_19_3 Node1_30_19 Node2_30_19 10240.000000000002
R_1_30_20_1 Node1_30_20 Node1_30_21 2.5000000000000004
R_1_30_20_2 Node1_30_20 Node1_31_20 2.5000000000000004
R_1_30_20_3 Node1_30_20 Node2_30_20 10240.000000000002
R_1_30_21_1 Node1_30_21 Node1_30_22 2.5000000000000004
R_1_30_21_2 Node1_30_21 Node1_31_21 2.5000000000000004
R_1_30_21_3 Node1_30_21 Node2_30_21 10240.000000000002
R_1_30_22_1 Node1_30_22 Node1_30_23 2.5000000000000004
R_1_30_22_2 Node1_30_22 Node1_31_22 2.5000000000000004
R_1_30_22_3 Node1_30_22 Node2_30_22 10240.000000000002
R_1_30_23_1 Node1_30_23 Node1_30_24 2.5000000000000004
R_1_30_23_2 Node1_30_23 Node1_31_23 2.5000000000000004
R_1_30_23_3 Node1_30_23 Node2_30_23 10240.000000000002
R_1_30_24_1 Node1_30_24 Node1_30_25 2.5000000000000004
R_1_30_24_2 Node1_30_24 Node1_31_24 2.5000000000000004
R_1_30_24_3 Node1_30_24 Node2_30_24 10240.000000000002
R_1_30_25_1 Node1_30_25 Node1_30_26 2.5000000000000004
R_1_30_25_2 Node1_30_25 Node1_31_25 2.5000000000000004
R_1_30_25_3 Node1_30_25 Node2_30_25 10240.000000000002
R_1_30_26_1 Node1_30_26 Node1_30_27 2.5000000000000004
R_1_30_26_2 Node1_30_26 Node1_31_26 2.5000000000000004
R_1_30_26_3 Node1_30_26 Node2_30_26 10240.000000000002
R_1_30_27_1 Node1_30_27 Node1_30_28 2.5000000000000004
R_1_30_27_2 Node1_30_27 Node1_31_27 2.5000000000000004
R_1_30_27_3 Node1_30_27 Node2_30_27 10240.000000000002
R_1_30_28_1 Node1_30_28 Node1_30_29 2.5000000000000004
R_1_30_28_2 Node1_30_28 Node1_31_28 2.5000000000000004
R_1_30_28_3 Node1_30_28 Node2_30_28 10240.000000000002
R_1_30_29_1 Node1_30_29 Node1_30_30 2.5000000000000004
R_1_30_29_2 Node1_30_29 Node1_31_29 2.5000000000000004
R_1_30_29_3 Node1_30_29 Node2_30_29 10240.000000000002
R_1_30_30_1 Node1_30_30 Node1_30_31 2.5000000000000004
R_1_30_30_2 Node1_30_30 Node1_31_30 2.5000000000000004
R_1_30_30_3 Node1_30_30 Node2_30_30 10240.000000000002
Rsp_1_30_31_1 Node1_30_31 Node_sp_right 71.54069767441861
R_1_30_31_2 Node1_30_31 Node1_31_31 2.5000000000000004
R_1_30_31_3 Node1_30_31 Node2_30_31 10240.000000000002
R_1_31_0_1 Node1_31_0 Node1_31_1 2.5000000000000004
Rsp_1_31_0_1 Node1_31_0 Node_sp_left 71.54069767441861
Rsp_1_31_0_2 Node1_31_0 Node_sp_top 71.54069767441861
R_1_31_0_3 Node1_31_0 Node2_31_0 10240.000000000002
R_1_31_1_1 Node1_31_1 Node1_31_2 2.5000000000000004
Rsp_1_31_1_2 Node1_31_1 Node_sp_top 71.54069767441861
R_1_31_1_3 Node1_31_1 Node2_31_1 10240.000000000002
R_1_31_2_1 Node1_31_2 Node1_31_3 2.5000000000000004
Rsp_1_31_2_2 Node1_31_2 Node_sp_top 71.54069767441861
R_1_31_2_3 Node1_31_2 Node2_31_2 10240.000000000002
R_1_31_3_1 Node1_31_3 Node1_31_4 2.5000000000000004
Rsp_1_31_3_2 Node1_31_3 Node_sp_top 71.54069767441861
R_1_31_3_3 Node1_31_3 Node2_31_3 10240.000000000002
R_1_31_4_1 Node1_31_4 Node1_31_5 2.5000000000000004
Rsp_1_31_4_2 Node1_31_4 Node_sp_top 71.54069767441861
R_1_31_4_3 Node1_31_4 Node2_31_4 10240.000000000002
R_1_31_5_1 Node1_31_5 Node1_31_6 2.5000000000000004
Rsp_1_31_5_2 Node1_31_5 Node_sp_top 71.54069767441861
R_1_31_5_3 Node1_31_5 Node2_31_5 10240.000000000002
R_1_31_6_1 Node1_31_6 Node1_31_7 2.5000000000000004
Rsp_1_31_6_2 Node1_31_6 Node_sp_top 71.54069767441861
R_1_31_6_3 Node1_31_6 Node2_31_6 10240.000000000002
R_1_31_7_1 Node1_31_7 Node1_31_8 2.5000000000000004
Rsp_1_31_7_2 Node1_31_7 Node_sp_top 71.54069767441861
R_1_31_7_3 Node1_31_7 Node2_31_7 10240.000000000002
R_1_31_8_1 Node1_31_8 Node1_31_9 2.5000000000000004
Rsp_1_31_8_2 Node1_31_8 Node_sp_top 71.54069767441861
R_1_31_8_3 Node1_31_8 Node2_31_8 10240.000000000002
R_1_31_9_1 Node1_31_9 Node1_31_10 2.5000000000000004
Rsp_1_31_9_2 Node1_31_9 Node_sp_top 71.54069767441861
R_1_31_9_3 Node1_31_9 Node2_31_9 10240.000000000002
R_1_31_10_1 Node1_31_10 Node1_31_11 2.5000000000000004
Rsp_1_31_10_2 Node1_31_10 Node_sp_top 71.54069767441861
R_1_31_10_3 Node1_31_10 Node2_31_10 10240.000000000002
R_1_31_11_1 Node1_31_11 Node1_31_12 2.5000000000000004
Rsp_1_31_11_2 Node1_31_11 Node_sp_top 71.54069767441861
R_1_31_11_3 Node1_31_11 Node2_31_11 10240.000000000002
R_1_31_12_1 Node1_31_12 Node1_31_13 2.5000000000000004
Rsp_1_31_12_2 Node1_31_12 Node_sp_top 71.54069767441861
R_1_31_12_3 Node1_31_12 Node2_31_12 10240.000000000002
R_1_31_13_1 Node1_31_13 Node1_31_14 2.5000000000000004
Rsp_1_31_13_2 Node1_31_13 Node_sp_top 71.54069767441861
R_1_31_13_3 Node1_31_13 Node2_31_13 10240.000000000002
R_1_31_14_1 Node1_31_14 Node1_31_15 2.5000000000000004
Rsp_1_31_14_2 Node1_31_14 Node_sp_top 71.54069767441861
R_1_31_14_3 Node1_31_14 Node2_31_14 10240.000000000002
R_1_31_15_1 Node1_31_15 Node1_31_16 2.5000000000000004
Rsp_1_31_15_2 Node1_31_15 Node_sp_top 71.54069767441861
R_1_31_15_3 Node1_31_15 Node2_31_15 10240.000000000002
R_1_31_16_1 Node1_31_16 Node1_31_17 2.5000000000000004
Rsp_1_31_16_2 Node1_31_16 Node_sp_top 71.54069767441861
R_1_31_16_3 Node1_31_16 Node2_31_16 10240.000000000002
R_1_31_17_1 Node1_31_17 Node1_31_18 2.5000000000000004
Rsp_1_31_17_2 Node1_31_17 Node_sp_top 71.54069767441861
R_1_31_17_3 Node1_31_17 Node2_31_17 10240.000000000002
R_1_31_18_1 Node1_31_18 Node1_31_19 2.5000000000000004
Rsp_1_31_18_2 Node1_31_18 Node_sp_top 71.54069767441861
R_1_31_18_3 Node1_31_18 Node2_31_18 10240.000000000002
R_1_31_19_1 Node1_31_19 Node1_31_20 2.5000000000000004
Rsp_1_31_19_2 Node1_31_19 Node_sp_top 71.54069767441861
R_1_31_19_3 Node1_31_19 Node2_31_19 10240.000000000002
R_1_31_20_1 Node1_31_20 Node1_31_21 2.5000000000000004
Rsp_1_31_20_2 Node1_31_20 Node_sp_top 71.54069767441861
R_1_31_20_3 Node1_31_20 Node2_31_20 10240.000000000002
R_1_31_21_1 Node1_31_21 Node1_31_22 2.5000000000000004
Rsp_1_31_21_2 Node1_31_21 Node_sp_top 71.54069767441861
R_1_31_21_3 Node1_31_21 Node2_31_21 10240.000000000002
R_1_31_22_1 Node1_31_22 Node1_31_23 2.5000000000000004
Rsp_1_31_22_2 Node1_31_22 Node_sp_top 71.54069767441861
R_1_31_22_3 Node1_31_22 Node2_31_22 10240.000000000002
R_1_31_23_1 Node1_31_23 Node1_31_24 2.5000000000000004
Rsp_1_31_23_2 Node1_31_23 Node_sp_top 71.54069767441861
R_1_31_23_3 Node1_31_23 Node2_31_23 10240.000000000002
R_1_31_24_1 Node1_31_24 Node1_31_25 2.5000000000000004
Rsp_1_31_24_2 Node1_31_24 Node_sp_top 71.54069767441861
R_1_31_24_3 Node1_31_24 Node2_31_24 10240.000000000002
R_1_31_25_1 Node1_31_25 Node1_31_26 2.5000000000000004
Rsp_1_31_25_2 Node1_31_25 Node_sp_top 71.54069767441861
R_1_31_25_3 Node1_31_25 Node2_31_25 10240.000000000002
R_1_31_26_1 Node1_31_26 Node1_31_27 2.5000000000000004
Rsp_1_31_26_2 Node1_31_26 Node_sp_top 71.54069767441861
R_1_31_26_3 Node1_31_26 Node2_31_26 10240.000000000002
R_1_31_27_1 Node1_31_27 Node1_31_28 2.5000000000000004
Rsp_1_31_27_2 Node1_31_27 Node_sp_top 71.54069767441861
R_1_31_27_3 Node1_31_27 Node2_31_27 10240.000000000002
R_1_31_28_1 Node1_31_28 Node1_31_29 2.5000000000000004
Rsp_1_31_28_2 Node1_31_28 Node_sp_top 71.54069767441861
R_1_31_28_3 Node1_31_28 Node2_31_28 10240.000000000002
R_1_31_29_1 Node1_31_29 Node1_31_30 2.5000000000000004
Rsp_1_31_29_2 Node1_31_29 Node_sp_top 71.54069767441861
R_1_31_29_3 Node1_31_29 Node2_31_29 10240.000000000002
R_1_31_30_1 Node1_31_30 Node1_31_31 2.5000000000000004
Rsp_1_31_30_2 Node1_31_30 Node_sp_top 71.54069767441861
R_1_31_30_3 Node1_31_30 Node2_31_30 10240.000000000002
Rsp_1_31_31_1 Node1_31_31 Node_sp_right 71.54069767441861
Rsp_1_31_31_2 Node1_31_31 Node_sp_top 71.54069767441861
R_1_31_31_3 Node1_31_31 Node2_31_31 10240.000000000002
R_2_0_0_1 Node2_0_0 Node2_0_1 2.5000000000000004
Rhs_2_0_0_1 Node2_0_0 Node_hs_right 71.54069767441861
R_2_0_0_2 Node2_0_0 Node2_1_0 2.5000000000000004
Rhs_2_0_0_2 Node2_0_0 Node_hs_bot 71.54069767441861
R_2_0_0_3 Node2_0_0 GND 706560.0000000001
R_2_0_1_1 Node2_0_1 Node2_0_2 2.5000000000000004
R_2_0_1_2 Node2_0_1 Node2_1_1 2.5000000000000004
Rhs_2_0_1_2 Node2_0_1 Node_hs_bot 71.54069767441861
R_2_0_1_3 Node2_0_1 GND 706560.0000000001
R_2_0_2_1 Node2_0_2 Node2_0_3 2.5000000000000004
R_2_0_2_2 Node2_0_2 Node2_1_2 2.5000000000000004
Rhs_2_0_2_2 Node2_0_2 Node_hs_bot 71.54069767441861
R_2_0_2_3 Node2_0_2 GND 706560.0000000001
R_2_0_3_1 Node2_0_3 Node2_0_4 2.5000000000000004
R_2_0_3_2 Node2_0_3 Node2_1_3 2.5000000000000004
Rhs_2_0_3_2 Node2_0_3 Node_hs_bot 71.54069767441861
R_2_0_3_3 Node2_0_3 GND 706560.0000000001
R_2_0_4_1 Node2_0_4 Node2_0_5 2.5000000000000004
R_2_0_4_2 Node2_0_4 Node2_1_4 2.5000000000000004
Rhs_2_0_4_2 Node2_0_4 Node_hs_bot 71.54069767441861
R_2_0_4_3 Node2_0_4 GND 706560.0000000001
R_2_0_5_1 Node2_0_5 Node2_0_6 2.5000000000000004
R_2_0_5_2 Node2_0_5 Node2_1_5 2.5000000000000004
Rhs_2_0_5_2 Node2_0_5 Node_hs_bot 71.54069767441861
R_2_0_5_3 Node2_0_5 GND 706560.0000000001
R_2_0_6_1 Node2_0_6 Node2_0_7 2.5000000000000004
R_2_0_6_2 Node2_0_6 Node2_1_6 2.5000000000000004
Rhs_2_0_6_2 Node2_0_6 Node_hs_bot 71.54069767441861
R_2_0_6_3 Node2_0_6 GND 706560.0000000001
R_2_0_7_1 Node2_0_7 Node2_0_8 2.5000000000000004
R_2_0_7_2 Node2_0_7 Node2_1_7 2.5000000000000004
Rhs_2_0_7_2 Node2_0_7 Node_hs_bot 71.54069767441861
R_2_0_7_3 Node2_0_7 GND 706560.0000000001
R_2_0_8_1 Node2_0_8 Node2_0_9 2.5000000000000004
R_2_0_8_2 Node2_0_8 Node2_1_8 2.5000000000000004
Rhs_2_0_8_2 Node2_0_8 Node_hs_bot 71.54069767441861
R_2_0_8_3 Node2_0_8 GND 706560.0000000001
R_2_0_9_1 Node2_0_9 Node2_0_10 2.5000000000000004
R_2_0_9_2 Node2_0_9 Node2_1_9 2.5000000000000004
Rhs_2_0_9_2 Node2_0_9 Node_hs_bot 71.54069767441861
R_2_0_9_3 Node2_0_9 GND 706560.0000000001
R_2_0_10_1 Node2_0_10 Node2_0_11 2.5000000000000004
R_2_0_10_2 Node2_0_10 Node2_1_10 2.5000000000000004
Rhs_2_0_10_2 Node2_0_10 Node_hs_bot 71.54069767441861
R_2_0_10_3 Node2_0_10 GND 706560.0000000001
R_2_0_11_1 Node2_0_11 Node2_0_12 2.5000000000000004
R_2_0_11_2 Node2_0_11 Node2_1_11 2.5000000000000004
Rhs_2_0_11_2 Node2_0_11 Node_hs_bot 71.54069767441861
R_2_0_11_3 Node2_0_11 GND 706560.0000000001
R_2_0_12_1 Node2_0_12 Node2_0_13 2.5000000000000004
R_2_0_12_2 Node2_0_12 Node2_1_12 2.5000000000000004
Rhs_2_0_12_2 Node2_0_12 Node_hs_bot 71.54069767441861
R_2_0_12_3 Node2_0_12 GND 706560.0000000001
R_2_0_13_1 Node2_0_13 Node2_0_14 2.5000000000000004
R_2_0_13_2 Node2_0_13 Node2_1_13 2.5000000000000004
Rhs_2_0_13_2 Node2_0_13 Node_hs_bot 71.54069767441861
R_2_0_13_3 Node2_0_13 GND 706560.0000000001
R_2_0_14_1 Node2_0_14 Node2_0_15 2.5000000000000004
R_2_0_14_2 Node2_0_14 Node2_1_14 2.5000000000000004
Rhs_2_0_14_2 Node2_0_14 Node_hs_bot 71.54069767441861
R_2_0_14_3 Node2_0_14 GND 706560.0000000001
R_2_0_15_1 Node2_0_15 Node2_0_16 2.5000000000000004
R_2_0_15_2 Node2_0_15 Node2_1_15 2.5000000000000004
Rhs_2_0_15_2 Node2_0_15 Node_hs_bot 71.54069767441861
R_2_0_15_3 Node2_0_15 GND 706560.0000000001
R_2_0_16_1 Node2_0_16 Node2_0_17 2.5000000000000004
R_2_0_16_2 Node2_0_16 Node2_1_16 2.5000000000000004
Rhs_2_0_16_2 Node2_0_16 Node_hs_bot 71.54069767441861
R_2_0_16_3 Node2_0_16 GND 706560.0000000001
R_2_0_17_1 Node2_0_17 Node2_0_18 2.5000000000000004
R_2_0_17_2 Node2_0_17 Node2_1_17 2.5000000000000004
Rhs_2_0_17_2 Node2_0_17 Node_hs_bot 71.54069767441861
R_2_0_17_3 Node2_0_17 GND 706560.0000000001
R_2_0_18_1 Node2_0_18 Node2_0_19 2.5000000000000004
R_2_0_18_2 Node2_0_18 Node2_1_18 2.5000000000000004
Rhs_2_0_18_2 Node2_0_18 Node_hs_bot 71.54069767441861
R_2_0_18_3 Node2_0_18 GND 706560.0000000001
R_2_0_19_1 Node2_0_19 Node2_0_20 2.5000000000000004
R_2_0_19_2 Node2_0_19 Node2_1_19 2.5000000000000004
Rhs_2_0_19_2 Node2_0_19 Node_hs_bot 71.54069767441861
R_2_0_19_3 Node2_0_19 GND 706560.0000000001
R_2_0_20_1 Node2_0_20 Node2_0_21 2.5000000000000004
R_2_0_20_2 Node2_0_20 Node2_1_20 2.5000000000000004
Rhs_2_0_20_2 Node2_0_20 Node_hs_bot 71.54069767441861
R_2_0_20_3 Node2_0_20 GND 706560.0000000001
R_2_0_21_1 Node2_0_21 Node2_0_22 2.5000000000000004
R_2_0_21_2 Node2_0_21 Node2_1_21 2.5000000000000004
Rhs_2_0_21_2 Node2_0_21 Node_hs_bot 71.54069767441861
R_2_0_21_3 Node2_0_21 GND 706560.0000000001
R_2_0_22_1 Node2_0_22 Node2_0_23 2.5000000000000004
R_2_0_22_2 Node2_0_22 Node2_1_22 2.5000000000000004
Rhs_2_0_22_2 Node2_0_22 Node_hs_bot 71.54069767441861
R_2_0_22_3 Node2_0_22 GND 706560.0000000001
R_2_0_23_1 Node2_0_23 Node2_0_24 2.5000000000000004
R_2_0_23_2 Node2_0_23 Node2_1_23 2.5000000000000004
Rhs_2_0_23_2 Node2_0_23 Node_hs_bot 71.54069767441861
R_2_0_23_3 Node2_0_23 GND 706560.0000000001
R_2_0_24_1 Node2_0_24 Node2_0_25 2.5000000000000004
R_2_0_24_2 Node2_0_24 Node2_1_24 2.5000000000000004
Rhs_2_0_24_2 Node2_0_24 Node_hs_bot 71.54069767441861
R_2_0_24_3 Node2_0_24 GND 706560.0000000001
R_2_0_25_1 Node2_0_25 Node2_0_26 2.5000000000000004
R_2_0_25_2 Node2_0_25 Node2_1_25 2.5000000000000004
Rhs_2_0_25_2 Node2_0_25 Node_hs_bot 71.54069767441861
R_2_0_25_3 Node2_0_25 GND 706560.0000000001
R_2_0_26_1 Node2_0_26 Node2_0_27 2.5000000000000004
R_2_0_26_2 Node2_0_26 Node2_1_26 2.5000000000000004
Rhs_2_0_26_2 Node2_0_26 Node_hs_bot 71.54069767441861
R_2_0_26_3 Node2_0_26 GND 706560.0000000001
R_2_0_27_1 Node2_0_27 Node2_0_28 2.5000000000000004
R_2_0_27_2 Node2_0_27 Node2_1_27 2.5000000000000004
Rhs_2_0_27_2 Node2_0_27 Node_hs_bot 71.54069767441861
R_2_0_27_3 Node2_0_27 GND 706560.0000000001
R_2_0_28_1 Node2_0_28 Node2_0_29 2.5000000000000004
R_2_0_28_2 Node2_0_28 Node2_1_28 2.5000000000000004
Rhs_2_0_28_2 Node2_0_28 Node_hs_bot 71.54069767441861
R_2_0_28_3 Node2_0_28 GND 706560.0000000001
R_2_0_29_1 Node2_0_29 Node2_0_30 2.5000000000000004
R_2_0_29_2 Node2_0_29 Node2_1_29 2.5000000000000004
Rhs_2_0_29_2 Node2_0_29 Node_hs_bot 71.54069767441861
R_2_0_29_3 Node2_0_29 GND 706560.0000000001
R_2_0_30_1 Node2_0_30 Node2_0_31 2.5000000000000004
R_2_0_30_2 Node2_0_30 Node2_1_30 2.5000000000000004
Rhs_2_0_30_2 Node2_0_30 Node_hs_bot 71.54069767441861
R_2_0_30_3 Node2_0_30 GND 706560.0000000001
Rhs_2_0_31_1 Node2_0_31 Node_hs_right 71.54069767441861
R_2_0_31_2 Node2_0_31 Node2_1_31 2.5000000000000004
Rhs_2_0_31_2 Node2_0_31 Node_hs_bot 71.54069767441861
R_2_0_31_3 Node2_0_31 GND 706560.0000000001
R_2_1_0_1 Node2_1_0 Node2_1_1 2.5000000000000004
Rhs_2_1_0_1 Node2_1_0 Node_hs_right 71.54069767441861
R_2_1_0_2 Node2_1_0 Node2_2_0 2.5000000000000004
R_2_1_0_3 Node2_1_0 GND 706560.0000000001
R_2_1_1_1 Node2_1_1 Node2_1_2 2.5000000000000004
R_2_1_1_2 Node2_1_1 Node2_2_1 2.5000000000000004
R_2_1_1_3 Node2_1_1 GND 706560.0000000001
R_2_1_2_1 Node2_1_2 Node2_1_3 2.5000000000000004
R_2_1_2_2 Node2_1_2 Node2_2_2 2.5000000000000004
R_2_1_2_3 Node2_1_2 GND 706560.0000000001
R_2_1_3_1 Node2_1_3 Node2_1_4 2.5000000000000004
R_2_1_3_2 Node2_1_3 Node2_2_3 2.5000000000000004
R_2_1_3_3 Node2_1_3 GND 706560.0000000001
R_2_1_4_1 Node2_1_4 Node2_1_5 2.5000000000000004
R_2_1_4_2 Node2_1_4 Node2_2_4 2.5000000000000004
R_2_1_4_3 Node2_1_4 GND 706560.0000000001
R_2_1_5_1 Node2_1_5 Node2_1_6 2.5000000000000004
R_2_1_5_2 Node2_1_5 Node2_2_5 2.5000000000000004
R_2_1_5_3 Node2_1_5 GND 706560.0000000001
R_2_1_6_1 Node2_1_6 Node2_1_7 2.5000000000000004
R_2_1_6_2 Node2_1_6 Node2_2_6 2.5000000000000004
R_2_1_6_3 Node2_1_6 GND 706560.0000000001
R_2_1_7_1 Node2_1_7 Node2_1_8 2.5000000000000004
R_2_1_7_2 Node2_1_7 Node2_2_7 2.5000000000000004
R_2_1_7_3 Node2_1_7 GND 706560.0000000001
R_2_1_8_1 Node2_1_8 Node2_1_9 2.5000000000000004
R_2_1_8_2 Node2_1_8 Node2_2_8 2.5000000000000004
R_2_1_8_3 Node2_1_8 GND 706560.0000000001
R_2_1_9_1 Node2_1_9 Node2_1_10 2.5000000000000004
R_2_1_9_2 Node2_1_9 Node2_2_9 2.5000000000000004
R_2_1_9_3 Node2_1_9 GND 706560.0000000001
R_2_1_10_1 Node2_1_10 Node2_1_11 2.5000000000000004
R_2_1_10_2 Node2_1_10 Node2_2_10 2.5000000000000004
R_2_1_10_3 Node2_1_10 GND 706560.0000000001
R_2_1_11_1 Node2_1_11 Node2_1_12 2.5000000000000004
R_2_1_11_2 Node2_1_11 Node2_2_11 2.5000000000000004
R_2_1_11_3 Node2_1_11 GND 706560.0000000001
R_2_1_12_1 Node2_1_12 Node2_1_13 2.5000000000000004
R_2_1_12_2 Node2_1_12 Node2_2_12 2.5000000000000004
R_2_1_12_3 Node2_1_12 GND 706560.0000000001
R_2_1_13_1 Node2_1_13 Node2_1_14 2.5000000000000004
R_2_1_13_2 Node2_1_13 Node2_2_13 2.5000000000000004
R_2_1_13_3 Node2_1_13 GND 706560.0000000001
R_2_1_14_1 Node2_1_14 Node2_1_15 2.5000000000000004
R_2_1_14_2 Node2_1_14 Node2_2_14 2.5000000000000004
R_2_1_14_3 Node2_1_14 GND 706560.0000000001
R_2_1_15_1 Node2_1_15 Node2_1_16 2.5000000000000004
R_2_1_15_2 Node2_1_15 Node2_2_15 2.5000000000000004
R_2_1_15_3 Node2_1_15 GND 706560.0000000001
R_2_1_16_1 Node2_1_16 Node2_1_17 2.5000000000000004
R_2_1_16_2 Node2_1_16 Node2_2_16 2.5000000000000004
R_2_1_16_3 Node2_1_16 GND 706560.0000000001
R_2_1_17_1 Node2_1_17 Node2_1_18 2.5000000000000004
R_2_1_17_2 Node2_1_17 Node2_2_17 2.5000000000000004
R_2_1_17_3 Node2_1_17 GND 706560.0000000001
R_2_1_18_1 Node2_1_18 Node2_1_19 2.5000000000000004
R_2_1_18_2 Node2_1_18 Node2_2_18 2.5000000000000004
R_2_1_18_3 Node2_1_18 GND 706560.0000000001
R_2_1_19_1 Node2_1_19 Node2_1_20 2.5000000000000004
R_2_1_19_2 Node2_1_19 Node2_2_19 2.5000000000000004
R_2_1_19_3 Node2_1_19 GND 706560.0000000001
R_2_1_20_1 Node2_1_20 Node2_1_21 2.5000000000000004
R_2_1_20_2 Node2_1_20 Node2_2_20 2.5000000000000004
R_2_1_20_3 Node2_1_20 GND 706560.0000000001
R_2_1_21_1 Node2_1_21 Node2_1_22 2.5000000000000004
R_2_1_21_2 Node2_1_21 Node2_2_21 2.5000000000000004
R_2_1_21_3 Node2_1_21 GND 706560.0000000001
R_2_1_22_1 Node2_1_22 Node2_1_23 2.5000000000000004
R_2_1_22_2 Node2_1_22 Node2_2_22 2.5000000000000004
R_2_1_22_3 Node2_1_22 GND 706560.0000000001
R_2_1_23_1 Node2_1_23 Node2_1_24 2.5000000000000004
R_2_1_23_2 Node2_1_23 Node2_2_23 2.5000000000000004
R_2_1_23_3 Node2_1_23 GND 706560.0000000001
R_2_1_24_1 Node2_1_24 Node2_1_25 2.5000000000000004
R_2_1_24_2 Node2_1_24 Node2_2_24 2.5000000000000004
R_2_1_24_3 Node2_1_24 GND 706560.0000000001
R_2_1_25_1 Node2_1_25 Node2_1_26 2.5000000000000004
R_2_1_25_2 Node2_1_25 Node2_2_25 2.5000000000000004
R_2_1_25_3 Node2_1_25 GND 706560.0000000001
R_2_1_26_1 Node2_1_26 Node2_1_27 2.5000000000000004
R_2_1_26_2 Node2_1_26 Node2_2_26 2.5000000000000004
R_2_1_26_3 Node2_1_26 GND 706560.0000000001
R_2_1_27_1 Node2_1_27 Node2_1_28 2.5000000000000004
R_2_1_27_2 Node2_1_27 Node2_2_27 2.5000000000000004
R_2_1_27_3 Node2_1_27 GND 706560.0000000001
R_2_1_28_1 Node2_1_28 Node2_1_29 2.5000000000000004
R_2_1_28_2 Node2_1_28 Node2_2_28 2.5000000000000004
R_2_1_28_3 Node2_1_28 GND 706560.0000000001
R_2_1_29_1 Node2_1_29 Node2_1_30 2.5000000000000004
R_2_1_29_2 Node2_1_29 Node2_2_29 2.5000000000000004
R_2_1_29_3 Node2_1_29 GND 706560.0000000001
R_2_1_30_1 Node2_1_30 Node2_1_31 2.5000000000000004
R_2_1_30_2 Node2_1_30 Node2_2_30 2.5000000000000004
R_2_1_30_3 Node2_1_30 GND 706560.0000000001
Rhs_2_1_31_1 Node2_1_31 Node_hs_right 71.54069767441861
R_2_1_31_2 Node2_1_31 Node2_2_31 2.5000000000000004
R_2_1_31_3 Node2_1_31 GND 706560.0000000001
R_2_2_0_1 Node2_2_0 Node2_2_1 2.5000000000000004
Rhs_2_2_0_1 Node2_2_0 Node_hs_right 71.54069767441861
R_2_2_0_2 Node2_2_0 Node2_3_0 2.5000000000000004
R_2_2_0_3 Node2_2_0 GND 706560.0000000001
R_2_2_1_1 Node2_2_1 Node2_2_2 2.5000000000000004
R_2_2_1_2 Node2_2_1 Node2_3_1 2.5000000000000004
R_2_2_1_3 Node2_2_1 GND 706560.0000000001
R_2_2_2_1 Node2_2_2 Node2_2_3 2.5000000000000004
R_2_2_2_2 Node2_2_2 Node2_3_2 2.5000000000000004
R_2_2_2_3 Node2_2_2 GND 706560.0000000001
R_2_2_3_1 Node2_2_3 Node2_2_4 2.5000000000000004
R_2_2_3_2 Node2_2_3 Node2_3_3 2.5000000000000004
R_2_2_3_3 Node2_2_3 GND 706560.0000000001
R_2_2_4_1 Node2_2_4 Node2_2_5 2.5000000000000004
R_2_2_4_2 Node2_2_4 Node2_3_4 2.5000000000000004
R_2_2_4_3 Node2_2_4 GND 706560.0000000001
R_2_2_5_1 Node2_2_5 Node2_2_6 2.5000000000000004
R_2_2_5_2 Node2_2_5 Node2_3_5 2.5000000000000004
R_2_2_5_3 Node2_2_5 GND 706560.0000000001
R_2_2_6_1 Node2_2_6 Node2_2_7 2.5000000000000004
R_2_2_6_2 Node2_2_6 Node2_3_6 2.5000000000000004
R_2_2_6_3 Node2_2_6 GND 706560.0000000001
R_2_2_7_1 Node2_2_7 Node2_2_8 2.5000000000000004
R_2_2_7_2 Node2_2_7 Node2_3_7 2.5000000000000004
R_2_2_7_3 Node2_2_7 GND 706560.0000000001
R_2_2_8_1 Node2_2_8 Node2_2_9 2.5000000000000004
R_2_2_8_2 Node2_2_8 Node2_3_8 2.5000000000000004
R_2_2_8_3 Node2_2_8 GND 706560.0000000001
R_2_2_9_1 Node2_2_9 Node2_2_10 2.5000000000000004
R_2_2_9_2 Node2_2_9 Node2_3_9 2.5000000000000004
R_2_2_9_3 Node2_2_9 GND 706560.0000000001
R_2_2_10_1 Node2_2_10 Node2_2_11 2.5000000000000004
R_2_2_10_2 Node2_2_10 Node2_3_10 2.5000000000000004
R_2_2_10_3 Node2_2_10 GND 706560.0000000001
R_2_2_11_1 Node2_2_11 Node2_2_12 2.5000000000000004
R_2_2_11_2 Node2_2_11 Node2_3_11 2.5000000000000004
R_2_2_11_3 Node2_2_11 GND 706560.0000000001
R_2_2_12_1 Node2_2_12 Node2_2_13 2.5000000000000004
R_2_2_12_2 Node2_2_12 Node2_3_12 2.5000000000000004
R_2_2_12_3 Node2_2_12 GND 706560.0000000001
R_2_2_13_1 Node2_2_13 Node2_2_14 2.5000000000000004
R_2_2_13_2 Node2_2_13 Node2_3_13 2.5000000000000004
R_2_2_13_3 Node2_2_13 GND 706560.0000000001
R_2_2_14_1 Node2_2_14 Node2_2_15 2.5000000000000004
R_2_2_14_2 Node2_2_14 Node2_3_14 2.5000000000000004
R_2_2_14_3 Node2_2_14 GND 706560.0000000001
R_2_2_15_1 Node2_2_15 Node2_2_16 2.5000000000000004
R_2_2_15_2 Node2_2_15 Node2_3_15 2.5000000000000004
R_2_2_15_3 Node2_2_15 GND 706560.0000000001
R_2_2_16_1 Node2_2_16 Node2_2_17 2.5000000000000004
R_2_2_16_2 Node2_2_16 Node2_3_16 2.5000000000000004
R_2_2_16_3 Node2_2_16 GND 706560.0000000001
R_2_2_17_1 Node2_2_17 Node2_2_18 2.5000000000000004
R_2_2_17_2 Node2_2_17 Node2_3_17 2.5000000000000004
R_2_2_17_3 Node2_2_17 GND 706560.0000000001
R_2_2_18_1 Node2_2_18 Node2_2_19 2.5000000000000004
R_2_2_18_2 Node2_2_18 Node2_3_18 2.5000000000000004
R_2_2_18_3 Node2_2_18 GND 706560.0000000001
R_2_2_19_1 Node2_2_19 Node2_2_20 2.5000000000000004
R_2_2_19_2 Node2_2_19 Node2_3_19 2.5000000000000004
R_2_2_19_3 Node2_2_19 GND 706560.0000000001
R_2_2_20_1 Node2_2_20 Node2_2_21 2.5000000000000004
R_2_2_20_2 Node2_2_20 Node2_3_20 2.5000000000000004
R_2_2_20_3 Node2_2_20 GND 706560.0000000001
R_2_2_21_1 Node2_2_21 Node2_2_22 2.5000000000000004
R_2_2_21_2 Node2_2_21 Node2_3_21 2.5000000000000004
R_2_2_21_3 Node2_2_21 GND 706560.0000000001
R_2_2_22_1 Node2_2_22 Node2_2_23 2.5000000000000004
R_2_2_22_2 Node2_2_22 Node2_3_22 2.5000000000000004
R_2_2_22_3 Node2_2_22 GND 706560.0000000001
R_2_2_23_1 Node2_2_23 Node2_2_24 2.5000000000000004
R_2_2_23_2 Node2_2_23 Node2_3_23 2.5000000000000004
R_2_2_23_3 Node2_2_23 GND 706560.0000000001
R_2_2_24_1 Node2_2_24 Node2_2_25 2.5000000000000004
R_2_2_24_2 Node2_2_24 Node2_3_24 2.5000000000000004
R_2_2_24_3 Node2_2_24 GND 706560.0000000001
R_2_2_25_1 Node2_2_25 Node2_2_26 2.5000000000000004
R_2_2_25_2 Node2_2_25 Node2_3_25 2.5000000000000004
R_2_2_25_3 Node2_2_25 GND 706560.0000000001
R_2_2_26_1 Node2_2_26 Node2_2_27 2.5000000000000004
R_2_2_26_2 Node2_2_26 Node2_3_26 2.5000000000000004
R_2_2_26_3 Node2_2_26 GND 706560.0000000001
R_2_2_27_1 Node2_2_27 Node2_2_28 2.5000000000000004
R_2_2_27_2 Node2_2_27 Node2_3_27 2.5000000000000004
R_2_2_27_3 Node2_2_27 GND 706560.0000000001
R_2_2_28_1 Node2_2_28 Node2_2_29 2.5000000000000004
R_2_2_28_2 Node2_2_28 Node2_3_28 2.5000000000000004
R_2_2_28_3 Node2_2_28 GND 706560.0000000001
R_2_2_29_1 Node2_2_29 Node2_2_30 2.5000000000000004
R_2_2_29_2 Node2_2_29 Node2_3_29 2.5000000000000004
R_2_2_29_3 Node2_2_29 GND 706560.0000000001
R_2_2_30_1 Node2_2_30 Node2_2_31 2.5000000000000004
R_2_2_30_2 Node2_2_30 Node2_3_30 2.5000000000000004
R_2_2_30_3 Node2_2_30 GND 706560.0000000001
Rhs_2_2_31_1 Node2_2_31 Node_hs_right 71.54069767441861
R_2_2_31_2 Node2_2_31 Node2_3_31 2.5000000000000004
R_2_2_31_3 Node2_2_31 GND 706560.0000000001
R_2_3_0_1 Node2_3_0 Node2_3_1 2.5000000000000004
Rhs_2_3_0_1 Node2_3_0 Node_hs_right 71.54069767441861
R_2_3_0_2 Node2_3_0 Node2_4_0 2.5000000000000004
R_2_3_0_3 Node2_3_0 GND 706560.0000000001
R_2_3_1_1 Node2_3_1 Node2_3_2 2.5000000000000004
R_2_3_1_2 Node2_3_1 Node2_4_1 2.5000000000000004
R_2_3_1_3 Node2_3_1 GND 706560.0000000001
R_2_3_2_1 Node2_3_2 Node2_3_3 2.5000000000000004
R_2_3_2_2 Node2_3_2 Node2_4_2 2.5000000000000004
R_2_3_2_3 Node2_3_2 GND 706560.0000000001
R_2_3_3_1 Node2_3_3 Node2_3_4 2.5000000000000004
R_2_3_3_2 Node2_3_3 Node2_4_3 2.5000000000000004
R_2_3_3_3 Node2_3_3 GND 706560.0000000001
R_2_3_4_1 Node2_3_4 Node2_3_5 2.5000000000000004
R_2_3_4_2 Node2_3_4 Node2_4_4 2.5000000000000004
R_2_3_4_3 Node2_3_4 GND 706560.0000000001
R_2_3_5_1 Node2_3_5 Node2_3_6 2.5000000000000004
R_2_3_5_2 Node2_3_5 Node2_4_5 2.5000000000000004
R_2_3_5_3 Node2_3_5 GND 706560.0000000001
R_2_3_6_1 Node2_3_6 Node2_3_7 2.5000000000000004
R_2_3_6_2 Node2_3_6 Node2_4_6 2.5000000000000004
R_2_3_6_3 Node2_3_6 GND 706560.0000000001
R_2_3_7_1 Node2_3_7 Node2_3_8 2.5000000000000004
R_2_3_7_2 Node2_3_7 Node2_4_7 2.5000000000000004
R_2_3_7_3 Node2_3_7 GND 706560.0000000001
R_2_3_8_1 Node2_3_8 Node2_3_9 2.5000000000000004
R_2_3_8_2 Node2_3_8 Node2_4_8 2.5000000000000004
R_2_3_8_3 Node2_3_8 GND 706560.0000000001
R_2_3_9_1 Node2_3_9 Node2_3_10 2.5000000000000004
R_2_3_9_2 Node2_3_9 Node2_4_9 2.5000000000000004
R_2_3_9_3 Node2_3_9 GND 706560.0000000001
R_2_3_10_1 Node2_3_10 Node2_3_11 2.5000000000000004
R_2_3_10_2 Node2_3_10 Node2_4_10 2.5000000000000004
R_2_3_10_3 Node2_3_10 GND 706560.0000000001
R_2_3_11_1 Node2_3_11 Node2_3_12 2.5000000000000004
R_2_3_11_2 Node2_3_11 Node2_4_11 2.5000000000000004
R_2_3_11_3 Node2_3_11 GND 706560.0000000001
R_2_3_12_1 Node2_3_12 Node2_3_13 2.5000000000000004
R_2_3_12_2 Node2_3_12 Node2_4_12 2.5000000000000004
R_2_3_12_3 Node2_3_12 GND 706560.0000000001
R_2_3_13_1 Node2_3_13 Node2_3_14 2.5000000000000004
R_2_3_13_2 Node2_3_13 Node2_4_13 2.5000000000000004
R_2_3_13_3 Node2_3_13 GND 706560.0000000001
R_2_3_14_1 Node2_3_14 Node2_3_15 2.5000000000000004
R_2_3_14_2 Node2_3_14 Node2_4_14 2.5000000000000004
R_2_3_14_3 Node2_3_14 GND 706560.0000000001
R_2_3_15_1 Node2_3_15 Node2_3_16 2.5000000000000004
R_2_3_15_2 Node2_3_15 Node2_4_15 2.5000000000000004
R_2_3_15_3 Node2_3_15 GND 706560.0000000001
R_2_3_16_1 Node2_3_16 Node2_3_17 2.5000000000000004
R_2_3_16_2 Node2_3_16 Node2_4_16 2.5000000000000004
R_2_3_16_3 Node2_3_16 GND 706560.0000000001
R_2_3_17_1 Node2_3_17 Node2_3_18 2.5000000000000004
R_2_3_17_2 Node2_3_17 Node2_4_17 2.5000000000000004
R_2_3_17_3 Node2_3_17 GND 706560.0000000001
R_2_3_18_1 Node2_3_18 Node2_3_19 2.5000000000000004
R_2_3_18_2 Node2_3_18 Node2_4_18 2.5000000000000004
R_2_3_18_3 Node2_3_18 GND 706560.0000000001
R_2_3_19_1 Node2_3_19 Node2_3_20 2.5000000000000004
R_2_3_19_2 Node2_3_19 Node2_4_19 2.5000000000000004
R_2_3_19_3 Node2_3_19 GND 706560.0000000001
R_2_3_20_1 Node2_3_20 Node2_3_21 2.5000000000000004
R_2_3_20_2 Node2_3_20 Node2_4_20 2.5000000000000004
R_2_3_20_3 Node2_3_20 GND 706560.0000000001
R_2_3_21_1 Node2_3_21 Node2_3_22 2.5000000000000004
R_2_3_21_2 Node2_3_21 Node2_4_21 2.5000000000000004
R_2_3_21_3 Node2_3_21 GND 706560.0000000001
R_2_3_22_1 Node2_3_22 Node2_3_23 2.5000000000000004
R_2_3_22_2 Node2_3_22 Node2_4_22 2.5000000000000004
R_2_3_22_3 Node2_3_22 GND 706560.0000000001
R_2_3_23_1 Node2_3_23 Node2_3_24 2.5000000000000004
R_2_3_23_2 Node2_3_23 Node2_4_23 2.5000000000000004
R_2_3_23_3 Node2_3_23 GND 706560.0000000001
R_2_3_24_1 Node2_3_24 Node2_3_25 2.5000000000000004
R_2_3_24_2 Node2_3_24 Node2_4_24 2.5000000000000004
R_2_3_24_3 Node2_3_24 GND 706560.0000000001
R_2_3_25_1 Node2_3_25 Node2_3_26 2.5000000000000004
R_2_3_25_2 Node2_3_25 Node2_4_25 2.5000000000000004
R_2_3_25_3 Node2_3_25 GND 706560.0000000001
R_2_3_26_1 Node2_3_26 Node2_3_27 2.5000000000000004
R_2_3_26_2 Node2_3_26 Node2_4_26 2.5000000000000004
R_2_3_26_3 Node2_3_26 GND 706560.0000000001
R_2_3_27_1 Node2_3_27 Node2_3_28 2.5000000000000004
R_2_3_27_2 Node2_3_27 Node2_4_27 2.5000000000000004
R_2_3_27_3 Node2_3_27 GND 706560.0000000001
R_2_3_28_1 Node2_3_28 Node2_3_29 2.5000000000000004
R_2_3_28_2 Node2_3_28 Node2_4_28 2.5000000000000004
R_2_3_28_3 Node2_3_28 GND 706560.0000000001
R_2_3_29_1 Node2_3_29 Node2_3_30 2.5000000000000004
R_2_3_29_2 Node2_3_29 Node2_4_29 2.5000000000000004
R_2_3_29_3 Node2_3_29 GND 706560.0000000001
R_2_3_30_1 Node2_3_30 Node2_3_31 2.5000000000000004
R_2_3_30_2 Node2_3_30 Node2_4_30 2.5000000000000004
R_2_3_30_3 Node2_3_30 GND 706560.0000000001
Rhs_2_3_31_1 Node2_3_31 Node_hs_right 71.54069767441861
R_2_3_31_2 Node2_3_31 Node2_4_31 2.5000000000000004
R_2_3_31_3 Node2_3_31 GND 706560.0000000001
R_2_4_0_1 Node2_4_0 Node2_4_1 2.5000000000000004
Rhs_2_4_0_1 Node2_4_0 Node_hs_right 71.54069767441861
R_2_4_0_2 Node2_4_0 Node2_5_0 2.5000000000000004
R_2_4_0_3 Node2_4_0 GND 706560.0000000001
R_2_4_1_1 Node2_4_1 Node2_4_2 2.5000000000000004
R_2_4_1_2 Node2_4_1 Node2_5_1 2.5000000000000004
R_2_4_1_3 Node2_4_1 GND 706560.0000000001
R_2_4_2_1 Node2_4_2 Node2_4_3 2.5000000000000004
R_2_4_2_2 Node2_4_2 Node2_5_2 2.5000000000000004
R_2_4_2_3 Node2_4_2 GND 706560.0000000001
R_2_4_3_1 Node2_4_3 Node2_4_4 2.5000000000000004
R_2_4_3_2 Node2_4_3 Node2_5_3 2.5000000000000004
R_2_4_3_3 Node2_4_3 GND 706560.0000000001
R_2_4_4_1 Node2_4_4 Node2_4_5 2.5000000000000004
R_2_4_4_2 Node2_4_4 Node2_5_4 2.5000000000000004
R_2_4_4_3 Node2_4_4 GND 706560.0000000001
R_2_4_5_1 Node2_4_5 Node2_4_6 2.5000000000000004
R_2_4_5_2 Node2_4_5 Node2_5_5 2.5000000000000004
R_2_4_5_3 Node2_4_5 GND 706560.0000000001
R_2_4_6_1 Node2_4_6 Node2_4_7 2.5000000000000004
R_2_4_6_2 Node2_4_6 Node2_5_6 2.5000000000000004
R_2_4_6_3 Node2_4_6 GND 706560.0000000001
R_2_4_7_1 Node2_4_7 Node2_4_8 2.5000000000000004
R_2_4_7_2 Node2_4_7 Node2_5_7 2.5000000000000004
R_2_4_7_3 Node2_4_7 GND 706560.0000000001
R_2_4_8_1 Node2_4_8 Node2_4_9 2.5000000000000004
R_2_4_8_2 Node2_4_8 Node2_5_8 2.5000000000000004
R_2_4_8_3 Node2_4_8 GND 706560.0000000001
R_2_4_9_1 Node2_4_9 Node2_4_10 2.5000000000000004
R_2_4_9_2 Node2_4_9 Node2_5_9 2.5000000000000004
R_2_4_9_3 Node2_4_9 GND 706560.0000000001
R_2_4_10_1 Node2_4_10 Node2_4_11 2.5000000000000004
R_2_4_10_2 Node2_4_10 Node2_5_10 2.5000000000000004
R_2_4_10_3 Node2_4_10 GND 706560.0000000001
R_2_4_11_1 Node2_4_11 Node2_4_12 2.5000000000000004
R_2_4_11_2 Node2_4_11 Node2_5_11 2.5000000000000004
R_2_4_11_3 Node2_4_11 GND 706560.0000000001
R_2_4_12_1 Node2_4_12 Node2_4_13 2.5000000000000004
R_2_4_12_2 Node2_4_12 Node2_5_12 2.5000000000000004
R_2_4_12_3 Node2_4_12 GND 706560.0000000001
R_2_4_13_1 Node2_4_13 Node2_4_14 2.5000000000000004
R_2_4_13_2 Node2_4_13 Node2_5_13 2.5000000000000004
R_2_4_13_3 Node2_4_13 GND 706560.0000000001
R_2_4_14_1 Node2_4_14 Node2_4_15 2.5000000000000004
R_2_4_14_2 Node2_4_14 Node2_5_14 2.5000000000000004
R_2_4_14_3 Node2_4_14 GND 706560.0000000001
R_2_4_15_1 Node2_4_15 Node2_4_16 2.5000000000000004
R_2_4_15_2 Node2_4_15 Node2_5_15 2.5000000000000004
R_2_4_15_3 Node2_4_15 GND 706560.0000000001
R_2_4_16_1 Node2_4_16 Node2_4_17 2.5000000000000004
R_2_4_16_2 Node2_4_16 Node2_5_16 2.5000000000000004
R_2_4_16_3 Node2_4_16 GND 706560.0000000001
R_2_4_17_1 Node2_4_17 Node2_4_18 2.5000000000000004
R_2_4_17_2 Node2_4_17 Node2_5_17 2.5000000000000004
R_2_4_17_3 Node2_4_17 GND 706560.0000000001
R_2_4_18_1 Node2_4_18 Node2_4_19 2.5000000000000004
R_2_4_18_2 Node2_4_18 Node2_5_18 2.5000000000000004
R_2_4_18_3 Node2_4_18 GND 706560.0000000001
R_2_4_19_1 Node2_4_19 Node2_4_20 2.5000000000000004
R_2_4_19_2 Node2_4_19 Node2_5_19 2.5000000000000004
R_2_4_19_3 Node2_4_19 GND 706560.0000000001
R_2_4_20_1 Node2_4_20 Node2_4_21 2.5000000000000004
R_2_4_20_2 Node2_4_20 Node2_5_20 2.5000000000000004
R_2_4_20_3 Node2_4_20 GND 706560.0000000001
R_2_4_21_1 Node2_4_21 Node2_4_22 2.5000000000000004
R_2_4_21_2 Node2_4_21 Node2_5_21 2.5000000000000004
R_2_4_21_3 Node2_4_21 GND 706560.0000000001
R_2_4_22_1 Node2_4_22 Node2_4_23 2.5000000000000004
R_2_4_22_2 Node2_4_22 Node2_5_22 2.5000000000000004
R_2_4_22_3 Node2_4_22 GND 706560.0000000001
R_2_4_23_1 Node2_4_23 Node2_4_24 2.5000000000000004
R_2_4_23_2 Node2_4_23 Node2_5_23 2.5000000000000004
R_2_4_23_3 Node2_4_23 GND 706560.0000000001
R_2_4_24_1 Node2_4_24 Node2_4_25 2.5000000000000004
R_2_4_24_2 Node2_4_24 Node2_5_24 2.5000000000000004
R_2_4_24_3 Node2_4_24 GND 706560.0000000001
R_2_4_25_1 Node2_4_25 Node2_4_26 2.5000000000000004
R_2_4_25_2 Node2_4_25 Node2_5_25 2.5000000000000004
R_2_4_25_3 Node2_4_25 GND 706560.0000000001
R_2_4_26_1 Node2_4_26 Node2_4_27 2.5000000000000004
R_2_4_26_2 Node2_4_26 Node2_5_26 2.5000000000000004
R_2_4_26_3 Node2_4_26 GND 706560.0000000001
R_2_4_27_1 Node2_4_27 Node2_4_28 2.5000000000000004
R_2_4_27_2 Node2_4_27 Node2_5_27 2.5000000000000004
R_2_4_27_3 Node2_4_27 GND 706560.0000000001
R_2_4_28_1 Node2_4_28 Node2_4_29 2.5000000000000004
R_2_4_28_2 Node2_4_28 Node2_5_28 2.5000000000000004
R_2_4_28_3 Node2_4_28 GND 706560.0000000001
R_2_4_29_1 Node2_4_29 Node2_4_30 2.5000000000000004
R_2_4_29_2 Node2_4_29 Node2_5_29 2.5000000000000004
R_2_4_29_3 Node2_4_29 GND 706560.0000000001
R_2_4_30_1 Node2_4_30 Node2_4_31 2.5000000000000004
R_2_4_30_2 Node2_4_30 Node2_5_30 2.5000000000000004
R_2_4_30_3 Node2_4_30 GND 706560.0000000001
Rhs_2_4_31_1 Node2_4_31 Node_hs_right 71.54069767441861
R_2_4_31_2 Node2_4_31 Node2_5_31 2.5000000000000004
R_2_4_31_3 Node2_4_31 GND 706560.0000000001
R_2_5_0_1 Node2_5_0 Node2_5_1 2.5000000000000004
Rhs_2_5_0_1 Node2_5_0 Node_hs_right 71.54069767441861
R_2_5_0_2 Node2_5_0 Node2_6_0 2.5000000000000004
R_2_5_0_3 Node2_5_0 GND 706560.0000000001
R_2_5_1_1 Node2_5_1 Node2_5_2 2.5000000000000004
R_2_5_1_2 Node2_5_1 Node2_6_1 2.5000000000000004
R_2_5_1_3 Node2_5_1 GND 706560.0000000001
R_2_5_2_1 Node2_5_2 Node2_5_3 2.5000000000000004
R_2_5_2_2 Node2_5_2 Node2_6_2 2.5000000000000004
R_2_5_2_3 Node2_5_2 GND 706560.0000000001
R_2_5_3_1 Node2_5_3 Node2_5_4 2.5000000000000004
R_2_5_3_2 Node2_5_3 Node2_6_3 2.5000000000000004
R_2_5_3_3 Node2_5_3 GND 706560.0000000001
R_2_5_4_1 Node2_5_4 Node2_5_5 2.5000000000000004
R_2_5_4_2 Node2_5_4 Node2_6_4 2.5000000000000004
R_2_5_4_3 Node2_5_4 GND 706560.0000000001
R_2_5_5_1 Node2_5_5 Node2_5_6 2.5000000000000004
R_2_5_5_2 Node2_5_5 Node2_6_5 2.5000000000000004
R_2_5_5_3 Node2_5_5 GND 706560.0000000001
R_2_5_6_1 Node2_5_6 Node2_5_7 2.5000000000000004
R_2_5_6_2 Node2_5_6 Node2_6_6 2.5000000000000004
R_2_5_6_3 Node2_5_6 GND 706560.0000000001
R_2_5_7_1 Node2_5_7 Node2_5_8 2.5000000000000004
R_2_5_7_2 Node2_5_7 Node2_6_7 2.5000000000000004
R_2_5_7_3 Node2_5_7 GND 706560.0000000001
R_2_5_8_1 Node2_5_8 Node2_5_9 2.5000000000000004
R_2_5_8_2 Node2_5_8 Node2_6_8 2.5000000000000004
R_2_5_8_3 Node2_5_8 GND 706560.0000000001
R_2_5_9_1 Node2_5_9 Node2_5_10 2.5000000000000004
R_2_5_9_2 Node2_5_9 Node2_6_9 2.5000000000000004
R_2_5_9_3 Node2_5_9 GND 706560.0000000001
R_2_5_10_1 Node2_5_10 Node2_5_11 2.5000000000000004
R_2_5_10_2 Node2_5_10 Node2_6_10 2.5000000000000004
R_2_5_10_3 Node2_5_10 GND 706560.0000000001
R_2_5_11_1 Node2_5_11 Node2_5_12 2.5000000000000004
R_2_5_11_2 Node2_5_11 Node2_6_11 2.5000000000000004
R_2_5_11_3 Node2_5_11 GND 706560.0000000001
R_2_5_12_1 Node2_5_12 Node2_5_13 2.5000000000000004
R_2_5_12_2 Node2_5_12 Node2_6_12 2.5000000000000004
R_2_5_12_3 Node2_5_12 GND 706560.0000000001
R_2_5_13_1 Node2_5_13 Node2_5_14 2.5000000000000004
R_2_5_13_2 Node2_5_13 Node2_6_13 2.5000000000000004
R_2_5_13_3 Node2_5_13 GND 706560.0000000001
R_2_5_14_1 Node2_5_14 Node2_5_15 2.5000000000000004
R_2_5_14_2 Node2_5_14 Node2_6_14 2.5000000000000004
R_2_5_14_3 Node2_5_14 GND 706560.0000000001
R_2_5_15_1 Node2_5_15 Node2_5_16 2.5000000000000004
R_2_5_15_2 Node2_5_15 Node2_6_15 2.5000000000000004
R_2_5_15_3 Node2_5_15 GND 706560.0000000001
R_2_5_16_1 Node2_5_16 Node2_5_17 2.5000000000000004
R_2_5_16_2 Node2_5_16 Node2_6_16 2.5000000000000004
R_2_5_16_3 Node2_5_16 GND 706560.0000000001
R_2_5_17_1 Node2_5_17 Node2_5_18 2.5000000000000004
R_2_5_17_2 Node2_5_17 Node2_6_17 2.5000000000000004
R_2_5_17_3 Node2_5_17 GND 706560.0000000001
R_2_5_18_1 Node2_5_18 Node2_5_19 2.5000000000000004
R_2_5_18_2 Node2_5_18 Node2_6_18 2.5000000000000004
R_2_5_18_3 Node2_5_18 GND 706560.0000000001
R_2_5_19_1 Node2_5_19 Node2_5_20 2.5000000000000004
R_2_5_19_2 Node2_5_19 Node2_6_19 2.5000000000000004
R_2_5_19_3 Node2_5_19 GND 706560.0000000001
R_2_5_20_1 Node2_5_20 Node2_5_21 2.5000000000000004
R_2_5_20_2 Node2_5_20 Node2_6_20 2.5000000000000004
R_2_5_20_3 Node2_5_20 GND 706560.0000000001
R_2_5_21_1 Node2_5_21 Node2_5_22 2.5000000000000004
R_2_5_21_2 Node2_5_21 Node2_6_21 2.5000000000000004
R_2_5_21_3 Node2_5_21 GND 706560.0000000001
R_2_5_22_1 Node2_5_22 Node2_5_23 2.5000000000000004
R_2_5_22_2 Node2_5_22 Node2_6_22 2.5000000000000004
R_2_5_22_3 Node2_5_22 GND 706560.0000000001
R_2_5_23_1 Node2_5_23 Node2_5_24 2.5000000000000004
R_2_5_23_2 Node2_5_23 Node2_6_23 2.5000000000000004
R_2_5_23_3 Node2_5_23 GND 706560.0000000001
R_2_5_24_1 Node2_5_24 Node2_5_25 2.5000000000000004
R_2_5_24_2 Node2_5_24 Node2_6_24 2.5000000000000004
R_2_5_24_3 Node2_5_24 GND 706560.0000000001
R_2_5_25_1 Node2_5_25 Node2_5_26 2.5000000000000004
R_2_5_25_2 Node2_5_25 Node2_6_25 2.5000000000000004
R_2_5_25_3 Node2_5_25 GND 706560.0000000001
R_2_5_26_1 Node2_5_26 Node2_5_27 2.5000000000000004
R_2_5_26_2 Node2_5_26 Node2_6_26 2.5000000000000004
R_2_5_26_3 Node2_5_26 GND 706560.0000000001
R_2_5_27_1 Node2_5_27 Node2_5_28 2.5000000000000004
R_2_5_27_2 Node2_5_27 Node2_6_27 2.5000000000000004
R_2_5_27_3 Node2_5_27 GND 706560.0000000001
R_2_5_28_1 Node2_5_28 Node2_5_29 2.5000000000000004
R_2_5_28_2 Node2_5_28 Node2_6_28 2.5000000000000004
R_2_5_28_3 Node2_5_28 GND 706560.0000000001
R_2_5_29_1 Node2_5_29 Node2_5_30 2.5000000000000004
R_2_5_29_2 Node2_5_29 Node2_6_29 2.5000000000000004
R_2_5_29_3 Node2_5_29 GND 706560.0000000001
R_2_5_30_1 Node2_5_30 Node2_5_31 2.5000000000000004
R_2_5_30_2 Node2_5_30 Node2_6_30 2.5000000000000004
R_2_5_30_3 Node2_5_30 GND 706560.0000000001
Rhs_2_5_31_1 Node2_5_31 Node_hs_right 71.54069767441861
R_2_5_31_2 Node2_5_31 Node2_6_31 2.5000000000000004
R_2_5_31_3 Node2_5_31 GND 706560.0000000001
R_2_6_0_1 Node2_6_0 Node2_6_1 2.5000000000000004
Rhs_2_6_0_1 Node2_6_0 Node_hs_right 71.54069767441861
R_2_6_0_2 Node2_6_0 Node2_7_0 2.5000000000000004
R_2_6_0_3 Node2_6_0 GND 706560.0000000001
R_2_6_1_1 Node2_6_1 Node2_6_2 2.5000000000000004
R_2_6_1_2 Node2_6_1 Node2_7_1 2.5000000000000004
R_2_6_1_3 Node2_6_1 GND 706560.0000000001
R_2_6_2_1 Node2_6_2 Node2_6_3 2.5000000000000004
R_2_6_2_2 Node2_6_2 Node2_7_2 2.5000000000000004
R_2_6_2_3 Node2_6_2 GND 706560.0000000001
R_2_6_3_1 Node2_6_3 Node2_6_4 2.5000000000000004
R_2_6_3_2 Node2_6_3 Node2_7_3 2.5000000000000004
R_2_6_3_3 Node2_6_3 GND 706560.0000000001
R_2_6_4_1 Node2_6_4 Node2_6_5 2.5000000000000004
R_2_6_4_2 Node2_6_4 Node2_7_4 2.5000000000000004
R_2_6_4_3 Node2_6_4 GND 706560.0000000001
R_2_6_5_1 Node2_6_5 Node2_6_6 2.5000000000000004
R_2_6_5_2 Node2_6_5 Node2_7_5 2.5000000000000004
R_2_6_5_3 Node2_6_5 GND 706560.0000000001
R_2_6_6_1 Node2_6_6 Node2_6_7 2.5000000000000004
R_2_6_6_2 Node2_6_6 Node2_7_6 2.5000000000000004
R_2_6_6_3 Node2_6_6 GND 706560.0000000001
R_2_6_7_1 Node2_6_7 Node2_6_8 2.5000000000000004
R_2_6_7_2 Node2_6_7 Node2_7_7 2.5000000000000004
R_2_6_7_3 Node2_6_7 GND 706560.0000000001
R_2_6_8_1 Node2_6_8 Node2_6_9 2.5000000000000004
R_2_6_8_2 Node2_6_8 Node2_7_8 2.5000000000000004
R_2_6_8_3 Node2_6_8 GND 706560.0000000001
R_2_6_9_1 Node2_6_9 Node2_6_10 2.5000000000000004
R_2_6_9_2 Node2_6_9 Node2_7_9 2.5000000000000004
R_2_6_9_3 Node2_6_9 GND 706560.0000000001
R_2_6_10_1 Node2_6_10 Node2_6_11 2.5000000000000004
R_2_6_10_2 Node2_6_10 Node2_7_10 2.5000000000000004
R_2_6_10_3 Node2_6_10 GND 706560.0000000001
R_2_6_11_1 Node2_6_11 Node2_6_12 2.5000000000000004
R_2_6_11_2 Node2_6_11 Node2_7_11 2.5000000000000004
R_2_6_11_3 Node2_6_11 GND 706560.0000000001
R_2_6_12_1 Node2_6_12 Node2_6_13 2.5000000000000004
R_2_6_12_2 Node2_6_12 Node2_7_12 2.5000000000000004
R_2_6_12_3 Node2_6_12 GND 706560.0000000001
R_2_6_13_1 Node2_6_13 Node2_6_14 2.5000000000000004
R_2_6_13_2 Node2_6_13 Node2_7_13 2.5000000000000004
R_2_6_13_3 Node2_6_13 GND 706560.0000000001
R_2_6_14_1 Node2_6_14 Node2_6_15 2.5000000000000004
R_2_6_14_2 Node2_6_14 Node2_7_14 2.5000000000000004
R_2_6_14_3 Node2_6_14 GND 706560.0000000001
R_2_6_15_1 Node2_6_15 Node2_6_16 2.5000000000000004
R_2_6_15_2 Node2_6_15 Node2_7_15 2.5000000000000004
R_2_6_15_3 Node2_6_15 GND 706560.0000000001
R_2_6_16_1 Node2_6_16 Node2_6_17 2.5000000000000004
R_2_6_16_2 Node2_6_16 Node2_7_16 2.5000000000000004
R_2_6_16_3 Node2_6_16 GND 706560.0000000001
R_2_6_17_1 Node2_6_17 Node2_6_18 2.5000000000000004
R_2_6_17_2 Node2_6_17 Node2_7_17 2.5000000000000004
R_2_6_17_3 Node2_6_17 GND 706560.0000000001
R_2_6_18_1 Node2_6_18 Node2_6_19 2.5000000000000004
R_2_6_18_2 Node2_6_18 Node2_7_18 2.5000000000000004
R_2_6_18_3 Node2_6_18 GND 706560.0000000001
R_2_6_19_1 Node2_6_19 Node2_6_20 2.5000000000000004
R_2_6_19_2 Node2_6_19 Node2_7_19 2.5000000000000004
R_2_6_19_3 Node2_6_19 GND 706560.0000000001
R_2_6_20_1 Node2_6_20 Node2_6_21 2.5000000000000004
R_2_6_20_2 Node2_6_20 Node2_7_20 2.5000000000000004
R_2_6_20_3 Node2_6_20 GND 706560.0000000001
R_2_6_21_1 Node2_6_21 Node2_6_22 2.5000000000000004
R_2_6_21_2 Node2_6_21 Node2_7_21 2.5000000000000004
R_2_6_21_3 Node2_6_21 GND 706560.0000000001
R_2_6_22_1 Node2_6_22 Node2_6_23 2.5000000000000004
R_2_6_22_2 Node2_6_22 Node2_7_22 2.5000000000000004
R_2_6_22_3 Node2_6_22 GND 706560.0000000001
R_2_6_23_1 Node2_6_23 Node2_6_24 2.5000000000000004
R_2_6_23_2 Node2_6_23 Node2_7_23 2.5000000000000004
R_2_6_23_3 Node2_6_23 GND 706560.0000000001
R_2_6_24_1 Node2_6_24 Node2_6_25 2.5000000000000004
R_2_6_24_2 Node2_6_24 Node2_7_24 2.5000000000000004
R_2_6_24_3 Node2_6_24 GND 706560.0000000001
R_2_6_25_1 Node2_6_25 Node2_6_26 2.5000000000000004
R_2_6_25_2 Node2_6_25 Node2_7_25 2.5000000000000004
R_2_6_25_3 Node2_6_25 GND 706560.0000000001
R_2_6_26_1 Node2_6_26 Node2_6_27 2.5000000000000004
R_2_6_26_2 Node2_6_26 Node2_7_26 2.5000000000000004
R_2_6_26_3 Node2_6_26 GND 706560.0000000001
R_2_6_27_1 Node2_6_27 Node2_6_28 2.5000000000000004
R_2_6_27_2 Node2_6_27 Node2_7_27 2.5000000000000004
R_2_6_27_3 Node2_6_27 GND 706560.0000000001
R_2_6_28_1 Node2_6_28 Node2_6_29 2.5000000000000004
R_2_6_28_2 Node2_6_28 Node2_7_28 2.5000000000000004
R_2_6_28_3 Node2_6_28 GND 706560.0000000001
R_2_6_29_1 Node2_6_29 Node2_6_30 2.5000000000000004
R_2_6_29_2 Node2_6_29 Node2_7_29 2.5000000000000004
R_2_6_29_3 Node2_6_29 GND 706560.0000000001
R_2_6_30_1 Node2_6_30 Node2_6_31 2.5000000000000004
R_2_6_30_2 Node2_6_30 Node2_7_30 2.5000000000000004
R_2_6_30_3 Node2_6_30 GND 706560.0000000001
Rhs_2_6_31_1 Node2_6_31 Node_hs_right 71.54069767441861
R_2_6_31_2 Node2_6_31 Node2_7_31 2.5000000000000004
R_2_6_31_3 Node2_6_31 GND 706560.0000000001
R_2_7_0_1 Node2_7_0 Node2_7_1 2.5000000000000004
Rhs_2_7_0_1 Node2_7_0 Node_hs_right 71.54069767441861
R_2_7_0_2 Node2_7_0 Node2_8_0 2.5000000000000004
R_2_7_0_3 Node2_7_0 GND 706560.0000000001
R_2_7_1_1 Node2_7_1 Node2_7_2 2.5000000000000004
R_2_7_1_2 Node2_7_1 Node2_8_1 2.5000000000000004
R_2_7_1_3 Node2_7_1 GND 706560.0000000001
R_2_7_2_1 Node2_7_2 Node2_7_3 2.5000000000000004
R_2_7_2_2 Node2_7_2 Node2_8_2 2.5000000000000004
R_2_7_2_3 Node2_7_2 GND 706560.0000000001
R_2_7_3_1 Node2_7_3 Node2_7_4 2.5000000000000004
R_2_7_3_2 Node2_7_3 Node2_8_3 2.5000000000000004
R_2_7_3_3 Node2_7_3 GND 706560.0000000001
R_2_7_4_1 Node2_7_4 Node2_7_5 2.5000000000000004
R_2_7_4_2 Node2_7_4 Node2_8_4 2.5000000000000004
R_2_7_4_3 Node2_7_4 GND 706560.0000000001
R_2_7_5_1 Node2_7_5 Node2_7_6 2.5000000000000004
R_2_7_5_2 Node2_7_5 Node2_8_5 2.5000000000000004
R_2_7_5_3 Node2_7_5 GND 706560.0000000001
R_2_7_6_1 Node2_7_6 Node2_7_7 2.5000000000000004
R_2_7_6_2 Node2_7_6 Node2_8_6 2.5000000000000004
R_2_7_6_3 Node2_7_6 GND 706560.0000000001
R_2_7_7_1 Node2_7_7 Node2_7_8 2.5000000000000004
R_2_7_7_2 Node2_7_7 Node2_8_7 2.5000000000000004
R_2_7_7_3 Node2_7_7 GND 706560.0000000001
R_2_7_8_1 Node2_7_8 Node2_7_9 2.5000000000000004
R_2_7_8_2 Node2_7_8 Node2_8_8 2.5000000000000004
R_2_7_8_3 Node2_7_8 GND 706560.0000000001
R_2_7_9_1 Node2_7_9 Node2_7_10 2.5000000000000004
R_2_7_9_2 Node2_7_9 Node2_8_9 2.5000000000000004
R_2_7_9_3 Node2_7_9 GND 706560.0000000001
R_2_7_10_1 Node2_7_10 Node2_7_11 2.5000000000000004
R_2_7_10_2 Node2_7_10 Node2_8_10 2.5000000000000004
R_2_7_10_3 Node2_7_10 GND 706560.0000000001
R_2_7_11_1 Node2_7_11 Node2_7_12 2.5000000000000004
R_2_7_11_2 Node2_7_11 Node2_8_11 2.5000000000000004
R_2_7_11_3 Node2_7_11 GND 706560.0000000001
R_2_7_12_1 Node2_7_12 Node2_7_13 2.5000000000000004
R_2_7_12_2 Node2_7_12 Node2_8_12 2.5000000000000004
R_2_7_12_3 Node2_7_12 GND 706560.0000000001
R_2_7_13_1 Node2_7_13 Node2_7_14 2.5000000000000004
R_2_7_13_2 Node2_7_13 Node2_8_13 2.5000000000000004
R_2_7_13_3 Node2_7_13 GND 706560.0000000001
R_2_7_14_1 Node2_7_14 Node2_7_15 2.5000000000000004
R_2_7_14_2 Node2_7_14 Node2_8_14 2.5000000000000004
R_2_7_14_3 Node2_7_14 GND 706560.0000000001
R_2_7_15_1 Node2_7_15 Node2_7_16 2.5000000000000004
R_2_7_15_2 Node2_7_15 Node2_8_15 2.5000000000000004
R_2_7_15_3 Node2_7_15 GND 706560.0000000001
R_2_7_16_1 Node2_7_16 Node2_7_17 2.5000000000000004
R_2_7_16_2 Node2_7_16 Node2_8_16 2.5000000000000004
R_2_7_16_3 Node2_7_16 GND 706560.0000000001
R_2_7_17_1 Node2_7_17 Node2_7_18 2.5000000000000004
R_2_7_17_2 Node2_7_17 Node2_8_17 2.5000000000000004
R_2_7_17_3 Node2_7_17 GND 706560.0000000001
R_2_7_18_1 Node2_7_18 Node2_7_19 2.5000000000000004
R_2_7_18_2 Node2_7_18 Node2_8_18 2.5000000000000004
R_2_7_18_3 Node2_7_18 GND 706560.0000000001
R_2_7_19_1 Node2_7_19 Node2_7_20 2.5000000000000004
R_2_7_19_2 Node2_7_19 Node2_8_19 2.5000000000000004
R_2_7_19_3 Node2_7_19 GND 706560.0000000001
R_2_7_20_1 Node2_7_20 Node2_7_21 2.5000000000000004
R_2_7_20_2 Node2_7_20 Node2_8_20 2.5000000000000004
R_2_7_20_3 Node2_7_20 GND 706560.0000000001
R_2_7_21_1 Node2_7_21 Node2_7_22 2.5000000000000004
R_2_7_21_2 Node2_7_21 Node2_8_21 2.5000000000000004
R_2_7_21_3 Node2_7_21 GND 706560.0000000001
R_2_7_22_1 Node2_7_22 Node2_7_23 2.5000000000000004
R_2_7_22_2 Node2_7_22 Node2_8_22 2.5000000000000004
R_2_7_22_3 Node2_7_22 GND 706560.0000000001
R_2_7_23_1 Node2_7_23 Node2_7_24 2.5000000000000004
R_2_7_23_2 Node2_7_23 Node2_8_23 2.5000000000000004
R_2_7_23_3 Node2_7_23 GND 706560.0000000001
R_2_7_24_1 Node2_7_24 Node2_7_25 2.5000000000000004
R_2_7_24_2 Node2_7_24 Node2_8_24 2.5000000000000004
R_2_7_24_3 Node2_7_24 GND 706560.0000000001
R_2_7_25_1 Node2_7_25 Node2_7_26 2.5000000000000004
R_2_7_25_2 Node2_7_25 Node2_8_25 2.5000000000000004
R_2_7_25_3 Node2_7_25 GND 706560.0000000001
R_2_7_26_1 Node2_7_26 Node2_7_27 2.5000000000000004
R_2_7_26_2 Node2_7_26 Node2_8_26 2.5000000000000004
R_2_7_26_3 Node2_7_26 GND 706560.0000000001
R_2_7_27_1 Node2_7_27 Node2_7_28 2.5000000000000004
R_2_7_27_2 Node2_7_27 Node2_8_27 2.5000000000000004
R_2_7_27_3 Node2_7_27 GND 706560.0000000001
R_2_7_28_1 Node2_7_28 Node2_7_29 2.5000000000000004
R_2_7_28_2 Node2_7_28 Node2_8_28 2.5000000000000004
R_2_7_28_3 Node2_7_28 GND 706560.0000000001
R_2_7_29_1 Node2_7_29 Node2_7_30 2.5000000000000004
R_2_7_29_2 Node2_7_29 Node2_8_29 2.5000000000000004
R_2_7_29_3 Node2_7_29 GND 706560.0000000001
R_2_7_30_1 Node2_7_30 Node2_7_31 2.5000000000000004
R_2_7_30_2 Node2_7_30 Node2_8_30 2.5000000000000004
R_2_7_30_3 Node2_7_30 GND 706560.0000000001
Rhs_2_7_31_1 Node2_7_31 Node_hs_right 71.54069767441861
R_2_7_31_2 Node2_7_31 Node2_8_31 2.5000000000000004
R_2_7_31_3 Node2_7_31 GND 706560.0000000001
R_2_8_0_1 Node2_8_0 Node2_8_1 2.5000000000000004
Rhs_2_8_0_1 Node2_8_0 Node_hs_right 71.54069767441861
R_2_8_0_2 Node2_8_0 Node2_9_0 2.5000000000000004
R_2_8_0_3 Node2_8_0 GND 706560.0000000001
R_2_8_1_1 Node2_8_1 Node2_8_2 2.5000000000000004
R_2_8_1_2 Node2_8_1 Node2_9_1 2.5000000000000004
R_2_8_1_3 Node2_8_1 GND 706560.0000000001
R_2_8_2_1 Node2_8_2 Node2_8_3 2.5000000000000004
R_2_8_2_2 Node2_8_2 Node2_9_2 2.5000000000000004
R_2_8_2_3 Node2_8_2 GND 706560.0000000001
R_2_8_3_1 Node2_8_3 Node2_8_4 2.5000000000000004
R_2_8_3_2 Node2_8_3 Node2_9_3 2.5000000000000004
R_2_8_3_3 Node2_8_3 GND 706560.0000000001
R_2_8_4_1 Node2_8_4 Node2_8_5 2.5000000000000004
R_2_8_4_2 Node2_8_4 Node2_9_4 2.5000000000000004
R_2_8_4_3 Node2_8_4 GND 706560.0000000001
R_2_8_5_1 Node2_8_5 Node2_8_6 2.5000000000000004
R_2_8_5_2 Node2_8_5 Node2_9_5 2.5000000000000004
R_2_8_5_3 Node2_8_5 GND 706560.0000000001
R_2_8_6_1 Node2_8_6 Node2_8_7 2.5000000000000004
R_2_8_6_2 Node2_8_6 Node2_9_6 2.5000000000000004
R_2_8_6_3 Node2_8_6 GND 706560.0000000001
R_2_8_7_1 Node2_8_7 Node2_8_8 2.5000000000000004
R_2_8_7_2 Node2_8_7 Node2_9_7 2.5000000000000004
R_2_8_7_3 Node2_8_7 GND 706560.0000000001
R_2_8_8_1 Node2_8_8 Node2_8_9 2.5000000000000004
R_2_8_8_2 Node2_8_8 Node2_9_8 2.5000000000000004
R_2_8_8_3 Node2_8_8 GND 706560.0000000001
R_2_8_9_1 Node2_8_9 Node2_8_10 2.5000000000000004
R_2_8_9_2 Node2_8_9 Node2_9_9 2.5000000000000004
R_2_8_9_3 Node2_8_9 GND 706560.0000000001
R_2_8_10_1 Node2_8_10 Node2_8_11 2.5000000000000004
R_2_8_10_2 Node2_8_10 Node2_9_10 2.5000000000000004
R_2_8_10_3 Node2_8_10 GND 706560.0000000001
R_2_8_11_1 Node2_8_11 Node2_8_12 2.5000000000000004
R_2_8_11_2 Node2_8_11 Node2_9_11 2.5000000000000004
R_2_8_11_3 Node2_8_11 GND 706560.0000000001
R_2_8_12_1 Node2_8_12 Node2_8_13 2.5000000000000004
R_2_8_12_2 Node2_8_12 Node2_9_12 2.5000000000000004
R_2_8_12_3 Node2_8_12 GND 706560.0000000001
R_2_8_13_1 Node2_8_13 Node2_8_14 2.5000000000000004
R_2_8_13_2 Node2_8_13 Node2_9_13 2.5000000000000004
R_2_8_13_3 Node2_8_13 GND 706560.0000000001
R_2_8_14_1 Node2_8_14 Node2_8_15 2.5000000000000004
R_2_8_14_2 Node2_8_14 Node2_9_14 2.5000000000000004
R_2_8_14_3 Node2_8_14 GND 706560.0000000001
R_2_8_15_1 Node2_8_15 Node2_8_16 2.5000000000000004
R_2_8_15_2 Node2_8_15 Node2_9_15 2.5000000000000004
R_2_8_15_3 Node2_8_15 GND 706560.0000000001
R_2_8_16_1 Node2_8_16 Node2_8_17 2.5000000000000004
R_2_8_16_2 Node2_8_16 Node2_9_16 2.5000000000000004
R_2_8_16_3 Node2_8_16 GND 706560.0000000001
R_2_8_17_1 Node2_8_17 Node2_8_18 2.5000000000000004
R_2_8_17_2 Node2_8_17 Node2_9_17 2.5000000000000004
R_2_8_17_3 Node2_8_17 GND 706560.0000000001
R_2_8_18_1 Node2_8_18 Node2_8_19 2.5000000000000004
R_2_8_18_2 Node2_8_18 Node2_9_18 2.5000000000000004
R_2_8_18_3 Node2_8_18 GND 706560.0000000001
R_2_8_19_1 Node2_8_19 Node2_8_20 2.5000000000000004
R_2_8_19_2 Node2_8_19 Node2_9_19 2.5000000000000004
R_2_8_19_3 Node2_8_19 GND 706560.0000000001
R_2_8_20_1 Node2_8_20 Node2_8_21 2.5000000000000004
R_2_8_20_2 Node2_8_20 Node2_9_20 2.5000000000000004
R_2_8_20_3 Node2_8_20 GND 706560.0000000001
R_2_8_21_1 Node2_8_21 Node2_8_22 2.5000000000000004
R_2_8_21_2 Node2_8_21 Node2_9_21 2.5000000000000004
R_2_8_21_3 Node2_8_21 GND 706560.0000000001
R_2_8_22_1 Node2_8_22 Node2_8_23 2.5000000000000004
R_2_8_22_2 Node2_8_22 Node2_9_22 2.5000000000000004
R_2_8_22_3 Node2_8_22 GND 706560.0000000001
R_2_8_23_1 Node2_8_23 Node2_8_24 2.5000000000000004
R_2_8_23_2 Node2_8_23 Node2_9_23 2.5000000000000004
R_2_8_23_3 Node2_8_23 GND 706560.0000000001
R_2_8_24_1 Node2_8_24 Node2_8_25 2.5000000000000004
R_2_8_24_2 Node2_8_24 Node2_9_24 2.5000000000000004
R_2_8_24_3 Node2_8_24 GND 706560.0000000001
R_2_8_25_1 Node2_8_25 Node2_8_26 2.5000000000000004
R_2_8_25_2 Node2_8_25 Node2_9_25 2.5000000000000004
R_2_8_25_3 Node2_8_25 GND 706560.0000000001
R_2_8_26_1 Node2_8_26 Node2_8_27 2.5000000000000004
R_2_8_26_2 Node2_8_26 Node2_9_26 2.5000000000000004
R_2_8_26_3 Node2_8_26 GND 706560.0000000001
R_2_8_27_1 Node2_8_27 Node2_8_28 2.5000000000000004
R_2_8_27_2 Node2_8_27 Node2_9_27 2.5000000000000004
R_2_8_27_3 Node2_8_27 GND 706560.0000000001
R_2_8_28_1 Node2_8_28 Node2_8_29 2.5000000000000004
R_2_8_28_2 Node2_8_28 Node2_9_28 2.5000000000000004
R_2_8_28_3 Node2_8_28 GND 706560.0000000001
R_2_8_29_1 Node2_8_29 Node2_8_30 2.5000000000000004
R_2_8_29_2 Node2_8_29 Node2_9_29 2.5000000000000004
R_2_8_29_3 Node2_8_29 GND 706560.0000000001
R_2_8_30_1 Node2_8_30 Node2_8_31 2.5000000000000004
R_2_8_30_2 Node2_8_30 Node2_9_30 2.5000000000000004
R_2_8_30_3 Node2_8_30 GND 706560.0000000001
Rhs_2_8_31_1 Node2_8_31 Node_hs_right 71.54069767441861
R_2_8_31_2 Node2_8_31 Node2_9_31 2.5000000000000004
R_2_8_31_3 Node2_8_31 GND 706560.0000000001
R_2_9_0_1 Node2_9_0 Node2_9_1 2.5000000000000004
Rhs_2_9_0_1 Node2_9_0 Node_hs_right 71.54069767441861
R_2_9_0_2 Node2_9_0 Node2_10_0 2.5000000000000004
R_2_9_0_3 Node2_9_0 GND 706560.0000000001
R_2_9_1_1 Node2_9_1 Node2_9_2 2.5000000000000004
R_2_9_1_2 Node2_9_1 Node2_10_1 2.5000000000000004
R_2_9_1_3 Node2_9_1 GND 706560.0000000001
R_2_9_2_1 Node2_9_2 Node2_9_3 2.5000000000000004
R_2_9_2_2 Node2_9_2 Node2_10_2 2.5000000000000004
R_2_9_2_3 Node2_9_2 GND 706560.0000000001
R_2_9_3_1 Node2_9_3 Node2_9_4 2.5000000000000004
R_2_9_3_2 Node2_9_3 Node2_10_3 2.5000000000000004
R_2_9_3_3 Node2_9_3 GND 706560.0000000001
R_2_9_4_1 Node2_9_4 Node2_9_5 2.5000000000000004
R_2_9_4_2 Node2_9_4 Node2_10_4 2.5000000000000004
R_2_9_4_3 Node2_9_4 GND 706560.0000000001
R_2_9_5_1 Node2_9_5 Node2_9_6 2.5000000000000004
R_2_9_5_2 Node2_9_5 Node2_10_5 2.5000000000000004
R_2_9_5_3 Node2_9_5 GND 706560.0000000001
R_2_9_6_1 Node2_9_6 Node2_9_7 2.5000000000000004
R_2_9_6_2 Node2_9_6 Node2_10_6 2.5000000000000004
R_2_9_6_3 Node2_9_6 GND 706560.0000000001
R_2_9_7_1 Node2_9_7 Node2_9_8 2.5000000000000004
R_2_9_7_2 Node2_9_7 Node2_10_7 2.5000000000000004
R_2_9_7_3 Node2_9_7 GND 706560.0000000001
R_2_9_8_1 Node2_9_8 Node2_9_9 2.5000000000000004
R_2_9_8_2 Node2_9_8 Node2_10_8 2.5000000000000004
R_2_9_8_3 Node2_9_8 GND 706560.0000000001
R_2_9_9_1 Node2_9_9 Node2_9_10 2.5000000000000004
R_2_9_9_2 Node2_9_9 Node2_10_9 2.5000000000000004
R_2_9_9_3 Node2_9_9 GND 706560.0000000001
R_2_9_10_1 Node2_9_10 Node2_9_11 2.5000000000000004
R_2_9_10_2 Node2_9_10 Node2_10_10 2.5000000000000004
R_2_9_10_3 Node2_9_10 GND 706560.0000000001
R_2_9_11_1 Node2_9_11 Node2_9_12 2.5000000000000004
R_2_9_11_2 Node2_9_11 Node2_10_11 2.5000000000000004
R_2_9_11_3 Node2_9_11 GND 706560.0000000001
R_2_9_12_1 Node2_9_12 Node2_9_13 2.5000000000000004
R_2_9_12_2 Node2_9_12 Node2_10_12 2.5000000000000004
R_2_9_12_3 Node2_9_12 GND 706560.0000000001
R_2_9_13_1 Node2_9_13 Node2_9_14 2.5000000000000004
R_2_9_13_2 Node2_9_13 Node2_10_13 2.5000000000000004
R_2_9_13_3 Node2_9_13 GND 706560.0000000001
R_2_9_14_1 Node2_9_14 Node2_9_15 2.5000000000000004
R_2_9_14_2 Node2_9_14 Node2_10_14 2.5000000000000004
R_2_9_14_3 Node2_9_14 GND 706560.0000000001
R_2_9_15_1 Node2_9_15 Node2_9_16 2.5000000000000004
R_2_9_15_2 Node2_9_15 Node2_10_15 2.5000000000000004
R_2_9_15_3 Node2_9_15 GND 706560.0000000001
R_2_9_16_1 Node2_9_16 Node2_9_17 2.5000000000000004
R_2_9_16_2 Node2_9_16 Node2_10_16 2.5000000000000004
R_2_9_16_3 Node2_9_16 GND 706560.0000000001
R_2_9_17_1 Node2_9_17 Node2_9_18 2.5000000000000004
R_2_9_17_2 Node2_9_17 Node2_10_17 2.5000000000000004
R_2_9_17_3 Node2_9_17 GND 706560.0000000001
R_2_9_18_1 Node2_9_18 Node2_9_19 2.5000000000000004
R_2_9_18_2 Node2_9_18 Node2_10_18 2.5000000000000004
R_2_9_18_3 Node2_9_18 GND 706560.0000000001
R_2_9_19_1 Node2_9_19 Node2_9_20 2.5000000000000004
R_2_9_19_2 Node2_9_19 Node2_10_19 2.5000000000000004
R_2_9_19_3 Node2_9_19 GND 706560.0000000001
R_2_9_20_1 Node2_9_20 Node2_9_21 2.5000000000000004
R_2_9_20_2 Node2_9_20 Node2_10_20 2.5000000000000004
R_2_9_20_3 Node2_9_20 GND 706560.0000000001
R_2_9_21_1 Node2_9_21 Node2_9_22 2.5000000000000004
R_2_9_21_2 Node2_9_21 Node2_10_21 2.5000000000000004
R_2_9_21_3 Node2_9_21 GND 706560.0000000001
R_2_9_22_1 Node2_9_22 Node2_9_23 2.5000000000000004
R_2_9_22_2 Node2_9_22 Node2_10_22 2.5000000000000004
R_2_9_22_3 Node2_9_22 GND 706560.0000000001
R_2_9_23_1 Node2_9_23 Node2_9_24 2.5000000000000004
R_2_9_23_2 Node2_9_23 Node2_10_23 2.5000000000000004
R_2_9_23_3 Node2_9_23 GND 706560.0000000001
R_2_9_24_1 Node2_9_24 Node2_9_25 2.5000000000000004
R_2_9_24_2 Node2_9_24 Node2_10_24 2.5000000000000004
R_2_9_24_3 Node2_9_24 GND 706560.0000000001
R_2_9_25_1 Node2_9_25 Node2_9_26 2.5000000000000004
R_2_9_25_2 Node2_9_25 Node2_10_25 2.5000000000000004
R_2_9_25_3 Node2_9_25 GND 706560.0000000001
R_2_9_26_1 Node2_9_26 Node2_9_27 2.5000000000000004
R_2_9_26_2 Node2_9_26 Node2_10_26 2.5000000000000004
R_2_9_26_3 Node2_9_26 GND 706560.0000000001
R_2_9_27_1 Node2_9_27 Node2_9_28 2.5000000000000004
R_2_9_27_2 Node2_9_27 Node2_10_27 2.5000000000000004
R_2_9_27_3 Node2_9_27 GND 706560.0000000001
R_2_9_28_1 Node2_9_28 Node2_9_29 2.5000000000000004
R_2_9_28_2 Node2_9_28 Node2_10_28 2.5000000000000004
R_2_9_28_3 Node2_9_28 GND 706560.0000000001
R_2_9_29_1 Node2_9_29 Node2_9_30 2.5000000000000004
R_2_9_29_2 Node2_9_29 Node2_10_29 2.5000000000000004
R_2_9_29_3 Node2_9_29 GND 706560.0000000001
R_2_9_30_1 Node2_9_30 Node2_9_31 2.5000000000000004
R_2_9_30_2 Node2_9_30 Node2_10_30 2.5000000000000004
R_2_9_30_3 Node2_9_30 GND 706560.0000000001
Rhs_2_9_31_1 Node2_9_31 Node_hs_right 71.54069767441861
R_2_9_31_2 Node2_9_31 Node2_10_31 2.5000000000000004
R_2_9_31_3 Node2_9_31 GND 706560.0000000001
R_2_10_0_1 Node2_10_0 Node2_10_1 2.5000000000000004
Rhs_2_10_0_1 Node2_10_0 Node_hs_right 71.54069767441861
R_2_10_0_2 Node2_10_0 Node2_11_0 2.5000000000000004
R_2_10_0_3 Node2_10_0 GND 706560.0000000001
R_2_10_1_1 Node2_10_1 Node2_10_2 2.5000000000000004
R_2_10_1_2 Node2_10_1 Node2_11_1 2.5000000000000004
R_2_10_1_3 Node2_10_1 GND 706560.0000000001
R_2_10_2_1 Node2_10_2 Node2_10_3 2.5000000000000004
R_2_10_2_2 Node2_10_2 Node2_11_2 2.5000000000000004
R_2_10_2_3 Node2_10_2 GND 706560.0000000001
R_2_10_3_1 Node2_10_3 Node2_10_4 2.5000000000000004
R_2_10_3_2 Node2_10_3 Node2_11_3 2.5000000000000004
R_2_10_3_3 Node2_10_3 GND 706560.0000000001
R_2_10_4_1 Node2_10_4 Node2_10_5 2.5000000000000004
R_2_10_4_2 Node2_10_4 Node2_11_4 2.5000000000000004
R_2_10_4_3 Node2_10_4 GND 706560.0000000001
R_2_10_5_1 Node2_10_5 Node2_10_6 2.5000000000000004
R_2_10_5_2 Node2_10_5 Node2_11_5 2.5000000000000004
R_2_10_5_3 Node2_10_5 GND 706560.0000000001
R_2_10_6_1 Node2_10_6 Node2_10_7 2.5000000000000004
R_2_10_6_2 Node2_10_6 Node2_11_6 2.5000000000000004
R_2_10_6_3 Node2_10_6 GND 706560.0000000001
R_2_10_7_1 Node2_10_7 Node2_10_8 2.5000000000000004
R_2_10_7_2 Node2_10_7 Node2_11_7 2.5000000000000004
R_2_10_7_3 Node2_10_7 GND 706560.0000000001
R_2_10_8_1 Node2_10_8 Node2_10_9 2.5000000000000004
R_2_10_8_2 Node2_10_8 Node2_11_8 2.5000000000000004
R_2_10_8_3 Node2_10_8 GND 706560.0000000001
R_2_10_9_1 Node2_10_9 Node2_10_10 2.5000000000000004
R_2_10_9_2 Node2_10_9 Node2_11_9 2.5000000000000004
R_2_10_9_3 Node2_10_9 GND 706560.0000000001
R_2_10_10_1 Node2_10_10 Node2_10_11 2.5000000000000004
R_2_10_10_2 Node2_10_10 Node2_11_10 2.5000000000000004
R_2_10_10_3 Node2_10_10 GND 706560.0000000001
R_2_10_11_1 Node2_10_11 Node2_10_12 2.5000000000000004
R_2_10_11_2 Node2_10_11 Node2_11_11 2.5000000000000004
R_2_10_11_3 Node2_10_11 GND 706560.0000000001
R_2_10_12_1 Node2_10_12 Node2_10_13 2.5000000000000004
R_2_10_12_2 Node2_10_12 Node2_11_12 2.5000000000000004
R_2_10_12_3 Node2_10_12 GND 706560.0000000001
R_2_10_13_1 Node2_10_13 Node2_10_14 2.5000000000000004
R_2_10_13_2 Node2_10_13 Node2_11_13 2.5000000000000004
R_2_10_13_3 Node2_10_13 GND 706560.0000000001
R_2_10_14_1 Node2_10_14 Node2_10_15 2.5000000000000004
R_2_10_14_2 Node2_10_14 Node2_11_14 2.5000000000000004
R_2_10_14_3 Node2_10_14 GND 706560.0000000001
R_2_10_15_1 Node2_10_15 Node2_10_16 2.5000000000000004
R_2_10_15_2 Node2_10_15 Node2_11_15 2.5000000000000004
R_2_10_15_3 Node2_10_15 GND 706560.0000000001
R_2_10_16_1 Node2_10_16 Node2_10_17 2.5000000000000004
R_2_10_16_2 Node2_10_16 Node2_11_16 2.5000000000000004
R_2_10_16_3 Node2_10_16 GND 706560.0000000001
R_2_10_17_1 Node2_10_17 Node2_10_18 2.5000000000000004
R_2_10_17_2 Node2_10_17 Node2_11_17 2.5000000000000004
R_2_10_17_3 Node2_10_17 GND 706560.0000000001
R_2_10_18_1 Node2_10_18 Node2_10_19 2.5000000000000004
R_2_10_18_2 Node2_10_18 Node2_11_18 2.5000000000000004
R_2_10_18_3 Node2_10_18 GND 706560.0000000001
R_2_10_19_1 Node2_10_19 Node2_10_20 2.5000000000000004
R_2_10_19_2 Node2_10_19 Node2_11_19 2.5000000000000004
R_2_10_19_3 Node2_10_19 GND 706560.0000000001
R_2_10_20_1 Node2_10_20 Node2_10_21 2.5000000000000004
R_2_10_20_2 Node2_10_20 Node2_11_20 2.5000000000000004
R_2_10_20_3 Node2_10_20 GND 706560.0000000001
R_2_10_21_1 Node2_10_21 Node2_10_22 2.5000000000000004
R_2_10_21_2 Node2_10_21 Node2_11_21 2.5000000000000004
R_2_10_21_3 Node2_10_21 GND 706560.0000000001
R_2_10_22_1 Node2_10_22 Node2_10_23 2.5000000000000004
R_2_10_22_2 Node2_10_22 Node2_11_22 2.5000000000000004
R_2_10_22_3 Node2_10_22 GND 706560.0000000001
R_2_10_23_1 Node2_10_23 Node2_10_24 2.5000000000000004
R_2_10_23_2 Node2_10_23 Node2_11_23 2.5000000000000004
R_2_10_23_3 Node2_10_23 GND 706560.0000000001
R_2_10_24_1 Node2_10_24 Node2_10_25 2.5000000000000004
R_2_10_24_2 Node2_10_24 Node2_11_24 2.5000000000000004
R_2_10_24_3 Node2_10_24 GND 706560.0000000001
R_2_10_25_1 Node2_10_25 Node2_10_26 2.5000000000000004
R_2_10_25_2 Node2_10_25 Node2_11_25 2.5000000000000004
R_2_10_25_3 Node2_10_25 GND 706560.0000000001
R_2_10_26_1 Node2_10_26 Node2_10_27 2.5000000000000004
R_2_10_26_2 Node2_10_26 Node2_11_26 2.5000000000000004
R_2_10_26_3 Node2_10_26 GND 706560.0000000001
R_2_10_27_1 Node2_10_27 Node2_10_28 2.5000000000000004
R_2_10_27_2 Node2_10_27 Node2_11_27 2.5000000000000004
R_2_10_27_3 Node2_10_27 GND 706560.0000000001
R_2_10_28_1 Node2_10_28 Node2_10_29 2.5000000000000004
R_2_10_28_2 Node2_10_28 Node2_11_28 2.5000000000000004
R_2_10_28_3 Node2_10_28 GND 706560.0000000001
R_2_10_29_1 Node2_10_29 Node2_10_30 2.5000000000000004
R_2_10_29_2 Node2_10_29 Node2_11_29 2.5000000000000004
R_2_10_29_3 Node2_10_29 GND 706560.0000000001
R_2_10_30_1 Node2_10_30 Node2_10_31 2.5000000000000004
R_2_10_30_2 Node2_10_30 Node2_11_30 2.5000000000000004
R_2_10_30_3 Node2_10_30 GND 706560.0000000001
Rhs_2_10_31_1 Node2_10_31 Node_hs_right 71.54069767441861
R_2_10_31_2 Node2_10_31 Node2_11_31 2.5000000000000004
R_2_10_31_3 Node2_10_31 GND 706560.0000000001
R_2_11_0_1 Node2_11_0 Node2_11_1 2.5000000000000004
Rhs_2_11_0_1 Node2_11_0 Node_hs_right 71.54069767441861
R_2_11_0_2 Node2_11_0 Node2_12_0 2.5000000000000004
R_2_11_0_3 Node2_11_0 GND 706560.0000000001
R_2_11_1_1 Node2_11_1 Node2_11_2 2.5000000000000004
R_2_11_1_2 Node2_11_1 Node2_12_1 2.5000000000000004
R_2_11_1_3 Node2_11_1 GND 706560.0000000001
R_2_11_2_1 Node2_11_2 Node2_11_3 2.5000000000000004
R_2_11_2_2 Node2_11_2 Node2_12_2 2.5000000000000004
R_2_11_2_3 Node2_11_2 GND 706560.0000000001
R_2_11_3_1 Node2_11_3 Node2_11_4 2.5000000000000004
R_2_11_3_2 Node2_11_3 Node2_12_3 2.5000000000000004
R_2_11_3_3 Node2_11_3 GND 706560.0000000001
R_2_11_4_1 Node2_11_4 Node2_11_5 2.5000000000000004
R_2_11_4_2 Node2_11_4 Node2_12_4 2.5000000000000004
R_2_11_4_3 Node2_11_4 GND 706560.0000000001
R_2_11_5_1 Node2_11_5 Node2_11_6 2.5000000000000004
R_2_11_5_2 Node2_11_5 Node2_12_5 2.5000000000000004
R_2_11_5_3 Node2_11_5 GND 706560.0000000001
R_2_11_6_1 Node2_11_6 Node2_11_7 2.5000000000000004
R_2_11_6_2 Node2_11_6 Node2_12_6 2.5000000000000004
R_2_11_6_3 Node2_11_6 GND 706560.0000000001
R_2_11_7_1 Node2_11_7 Node2_11_8 2.5000000000000004
R_2_11_7_2 Node2_11_7 Node2_12_7 2.5000000000000004
R_2_11_7_3 Node2_11_7 GND 706560.0000000001
R_2_11_8_1 Node2_11_8 Node2_11_9 2.5000000000000004
R_2_11_8_2 Node2_11_8 Node2_12_8 2.5000000000000004
R_2_11_8_3 Node2_11_8 GND 706560.0000000001
R_2_11_9_1 Node2_11_9 Node2_11_10 2.5000000000000004
R_2_11_9_2 Node2_11_9 Node2_12_9 2.5000000000000004
R_2_11_9_3 Node2_11_9 GND 706560.0000000001
R_2_11_10_1 Node2_11_10 Node2_11_11 2.5000000000000004
R_2_11_10_2 Node2_11_10 Node2_12_10 2.5000000000000004
R_2_11_10_3 Node2_11_10 GND 706560.0000000001
R_2_11_11_1 Node2_11_11 Node2_11_12 2.5000000000000004
R_2_11_11_2 Node2_11_11 Node2_12_11 2.5000000000000004
R_2_11_11_3 Node2_11_11 GND 706560.0000000001
R_2_11_12_1 Node2_11_12 Node2_11_13 2.5000000000000004
R_2_11_12_2 Node2_11_12 Node2_12_12 2.5000000000000004
R_2_11_12_3 Node2_11_12 GND 706560.0000000001
R_2_11_13_1 Node2_11_13 Node2_11_14 2.5000000000000004
R_2_11_13_2 Node2_11_13 Node2_12_13 2.5000000000000004
R_2_11_13_3 Node2_11_13 GND 706560.0000000001
R_2_11_14_1 Node2_11_14 Node2_11_15 2.5000000000000004
R_2_11_14_2 Node2_11_14 Node2_12_14 2.5000000000000004
R_2_11_14_3 Node2_11_14 GND 706560.0000000001
R_2_11_15_1 Node2_11_15 Node2_11_16 2.5000000000000004
R_2_11_15_2 Node2_11_15 Node2_12_15 2.5000000000000004
R_2_11_15_3 Node2_11_15 GND 706560.0000000001
R_2_11_16_1 Node2_11_16 Node2_11_17 2.5000000000000004
R_2_11_16_2 Node2_11_16 Node2_12_16 2.5000000000000004
R_2_11_16_3 Node2_11_16 GND 706560.0000000001
R_2_11_17_1 Node2_11_17 Node2_11_18 2.5000000000000004
R_2_11_17_2 Node2_11_17 Node2_12_17 2.5000000000000004
R_2_11_17_3 Node2_11_17 GND 706560.0000000001
R_2_11_18_1 Node2_11_18 Node2_11_19 2.5000000000000004
R_2_11_18_2 Node2_11_18 Node2_12_18 2.5000000000000004
R_2_11_18_3 Node2_11_18 GND 706560.0000000001
R_2_11_19_1 Node2_11_19 Node2_11_20 2.5000000000000004
R_2_11_19_2 Node2_11_19 Node2_12_19 2.5000000000000004
R_2_11_19_3 Node2_11_19 GND 706560.0000000001
R_2_11_20_1 Node2_11_20 Node2_11_21 2.5000000000000004
R_2_11_20_2 Node2_11_20 Node2_12_20 2.5000000000000004
R_2_11_20_3 Node2_11_20 GND 706560.0000000001
R_2_11_21_1 Node2_11_21 Node2_11_22 2.5000000000000004
R_2_11_21_2 Node2_11_21 Node2_12_21 2.5000000000000004
R_2_11_21_3 Node2_11_21 GND 706560.0000000001
R_2_11_22_1 Node2_11_22 Node2_11_23 2.5000000000000004
R_2_11_22_2 Node2_11_22 Node2_12_22 2.5000000000000004
R_2_11_22_3 Node2_11_22 GND 706560.0000000001
R_2_11_23_1 Node2_11_23 Node2_11_24 2.5000000000000004
R_2_11_23_2 Node2_11_23 Node2_12_23 2.5000000000000004
R_2_11_23_3 Node2_11_23 GND 706560.0000000001
R_2_11_24_1 Node2_11_24 Node2_11_25 2.5000000000000004
R_2_11_24_2 Node2_11_24 Node2_12_24 2.5000000000000004
R_2_11_24_3 Node2_11_24 GND 706560.0000000001
R_2_11_25_1 Node2_11_25 Node2_11_26 2.5000000000000004
R_2_11_25_2 Node2_11_25 Node2_12_25 2.5000000000000004
R_2_11_25_3 Node2_11_25 GND 706560.0000000001
R_2_11_26_1 Node2_11_26 Node2_11_27 2.5000000000000004
R_2_11_26_2 Node2_11_26 Node2_12_26 2.5000000000000004
R_2_11_26_3 Node2_11_26 GND 706560.0000000001
R_2_11_27_1 Node2_11_27 Node2_11_28 2.5000000000000004
R_2_11_27_2 Node2_11_27 Node2_12_27 2.5000000000000004
R_2_11_27_3 Node2_11_27 GND 706560.0000000001
R_2_11_28_1 Node2_11_28 Node2_11_29 2.5000000000000004
R_2_11_28_2 Node2_11_28 Node2_12_28 2.5000000000000004
R_2_11_28_3 Node2_11_28 GND 706560.0000000001
R_2_11_29_1 Node2_11_29 Node2_11_30 2.5000000000000004
R_2_11_29_2 Node2_11_29 Node2_12_29 2.5000000000000004
R_2_11_29_3 Node2_11_29 GND 706560.0000000001
R_2_11_30_1 Node2_11_30 Node2_11_31 2.5000000000000004
R_2_11_30_2 Node2_11_30 Node2_12_30 2.5000000000000004
R_2_11_30_3 Node2_11_30 GND 706560.0000000001
Rhs_2_11_31_1 Node2_11_31 Node_hs_right 71.54069767441861
R_2_11_31_2 Node2_11_31 Node2_12_31 2.5000000000000004
R_2_11_31_3 Node2_11_31 GND 706560.0000000001
R_2_12_0_1 Node2_12_0 Node2_12_1 2.5000000000000004
Rhs_2_12_0_1 Node2_12_0 Node_hs_right 71.54069767441861
R_2_12_0_2 Node2_12_0 Node2_13_0 2.5000000000000004
R_2_12_0_3 Node2_12_0 GND 706560.0000000001
R_2_12_1_1 Node2_12_1 Node2_12_2 2.5000000000000004
R_2_12_1_2 Node2_12_1 Node2_13_1 2.5000000000000004
R_2_12_1_3 Node2_12_1 GND 706560.0000000001
R_2_12_2_1 Node2_12_2 Node2_12_3 2.5000000000000004
R_2_12_2_2 Node2_12_2 Node2_13_2 2.5000000000000004
R_2_12_2_3 Node2_12_2 GND 706560.0000000001
R_2_12_3_1 Node2_12_3 Node2_12_4 2.5000000000000004
R_2_12_3_2 Node2_12_3 Node2_13_3 2.5000000000000004
R_2_12_3_3 Node2_12_3 GND 706560.0000000001
R_2_12_4_1 Node2_12_4 Node2_12_5 2.5000000000000004
R_2_12_4_2 Node2_12_4 Node2_13_4 2.5000000000000004
R_2_12_4_3 Node2_12_4 GND 706560.0000000001
R_2_12_5_1 Node2_12_5 Node2_12_6 2.5000000000000004
R_2_12_5_2 Node2_12_5 Node2_13_5 2.5000000000000004
R_2_12_5_3 Node2_12_5 GND 706560.0000000001
R_2_12_6_1 Node2_12_6 Node2_12_7 2.5000000000000004
R_2_12_6_2 Node2_12_6 Node2_13_6 2.5000000000000004
R_2_12_6_3 Node2_12_6 GND 706560.0000000001
R_2_12_7_1 Node2_12_7 Node2_12_8 2.5000000000000004
R_2_12_7_2 Node2_12_7 Node2_13_7 2.5000000000000004
R_2_12_7_3 Node2_12_7 GND 706560.0000000001
R_2_12_8_1 Node2_12_8 Node2_12_9 2.5000000000000004
R_2_12_8_2 Node2_12_8 Node2_13_8 2.5000000000000004
R_2_12_8_3 Node2_12_8 GND 706560.0000000001
R_2_12_9_1 Node2_12_9 Node2_12_10 2.5000000000000004
R_2_12_9_2 Node2_12_9 Node2_13_9 2.5000000000000004
R_2_12_9_3 Node2_12_9 GND 706560.0000000001
R_2_12_10_1 Node2_12_10 Node2_12_11 2.5000000000000004
R_2_12_10_2 Node2_12_10 Node2_13_10 2.5000000000000004
R_2_12_10_3 Node2_12_10 GND 706560.0000000001
R_2_12_11_1 Node2_12_11 Node2_12_12 2.5000000000000004
R_2_12_11_2 Node2_12_11 Node2_13_11 2.5000000000000004
R_2_12_11_3 Node2_12_11 GND 706560.0000000001
R_2_12_12_1 Node2_12_12 Node2_12_13 2.5000000000000004
R_2_12_12_2 Node2_12_12 Node2_13_12 2.5000000000000004
R_2_12_12_3 Node2_12_12 GND 706560.0000000001
R_2_12_13_1 Node2_12_13 Node2_12_14 2.5000000000000004
R_2_12_13_2 Node2_12_13 Node2_13_13 2.5000000000000004
R_2_12_13_3 Node2_12_13 GND 706560.0000000001
R_2_12_14_1 Node2_12_14 Node2_12_15 2.5000000000000004
R_2_12_14_2 Node2_12_14 Node2_13_14 2.5000000000000004
R_2_12_14_3 Node2_12_14 GND 706560.0000000001
R_2_12_15_1 Node2_12_15 Node2_12_16 2.5000000000000004
R_2_12_15_2 Node2_12_15 Node2_13_15 2.5000000000000004
R_2_12_15_3 Node2_12_15 GND 706560.0000000001
R_2_12_16_1 Node2_12_16 Node2_12_17 2.5000000000000004
R_2_12_16_2 Node2_12_16 Node2_13_16 2.5000000000000004
R_2_12_16_3 Node2_12_16 GND 706560.0000000001
R_2_12_17_1 Node2_12_17 Node2_12_18 2.5000000000000004
R_2_12_17_2 Node2_12_17 Node2_13_17 2.5000000000000004
R_2_12_17_3 Node2_12_17 GND 706560.0000000001
R_2_12_18_1 Node2_12_18 Node2_12_19 2.5000000000000004
R_2_12_18_2 Node2_12_18 Node2_13_18 2.5000000000000004
R_2_12_18_3 Node2_12_18 GND 706560.0000000001
R_2_12_19_1 Node2_12_19 Node2_12_20 2.5000000000000004
R_2_12_19_2 Node2_12_19 Node2_13_19 2.5000000000000004
R_2_12_19_3 Node2_12_19 GND 706560.0000000001
R_2_12_20_1 Node2_12_20 Node2_12_21 2.5000000000000004
R_2_12_20_2 Node2_12_20 Node2_13_20 2.5000000000000004
R_2_12_20_3 Node2_12_20 GND 706560.0000000001
R_2_12_21_1 Node2_12_21 Node2_12_22 2.5000000000000004
R_2_12_21_2 Node2_12_21 Node2_13_21 2.5000000000000004
R_2_12_21_3 Node2_12_21 GND 706560.0000000001
R_2_12_22_1 Node2_12_22 Node2_12_23 2.5000000000000004
R_2_12_22_2 Node2_12_22 Node2_13_22 2.5000000000000004
R_2_12_22_3 Node2_12_22 GND 706560.0000000001
R_2_12_23_1 Node2_12_23 Node2_12_24 2.5000000000000004
R_2_12_23_2 Node2_12_23 Node2_13_23 2.5000000000000004
R_2_12_23_3 Node2_12_23 GND 706560.0000000001
R_2_12_24_1 Node2_12_24 Node2_12_25 2.5000000000000004
R_2_12_24_2 Node2_12_24 Node2_13_24 2.5000000000000004
R_2_12_24_3 Node2_12_24 GND 706560.0000000001
R_2_12_25_1 Node2_12_25 Node2_12_26 2.5000000000000004
R_2_12_25_2 Node2_12_25 Node2_13_25 2.5000000000000004
R_2_12_25_3 Node2_12_25 GND 706560.0000000001
R_2_12_26_1 Node2_12_26 Node2_12_27 2.5000000000000004
R_2_12_26_2 Node2_12_26 Node2_13_26 2.5000000000000004
R_2_12_26_3 Node2_12_26 GND 706560.0000000001
R_2_12_27_1 Node2_12_27 Node2_12_28 2.5000000000000004
R_2_12_27_2 Node2_12_27 Node2_13_27 2.5000000000000004
R_2_12_27_3 Node2_12_27 GND 706560.0000000001
R_2_12_28_1 Node2_12_28 Node2_12_29 2.5000000000000004
R_2_12_28_2 Node2_12_28 Node2_13_28 2.5000000000000004
R_2_12_28_3 Node2_12_28 GND 706560.0000000001
R_2_12_29_1 Node2_12_29 Node2_12_30 2.5000000000000004
R_2_12_29_2 Node2_12_29 Node2_13_29 2.5000000000000004
R_2_12_29_3 Node2_12_29 GND 706560.0000000001
R_2_12_30_1 Node2_12_30 Node2_12_31 2.5000000000000004
R_2_12_30_2 Node2_12_30 Node2_13_30 2.5000000000000004
R_2_12_30_3 Node2_12_30 GND 706560.0000000001
Rhs_2_12_31_1 Node2_12_31 Node_hs_right 71.54069767441861
R_2_12_31_2 Node2_12_31 Node2_13_31 2.5000000000000004
R_2_12_31_3 Node2_12_31 GND 706560.0000000001
R_2_13_0_1 Node2_13_0 Node2_13_1 2.5000000000000004
Rhs_2_13_0_1 Node2_13_0 Node_hs_right 71.54069767441861
R_2_13_0_2 Node2_13_0 Node2_14_0 2.5000000000000004
R_2_13_0_3 Node2_13_0 GND 706560.0000000001
R_2_13_1_1 Node2_13_1 Node2_13_2 2.5000000000000004
R_2_13_1_2 Node2_13_1 Node2_14_1 2.5000000000000004
R_2_13_1_3 Node2_13_1 GND 706560.0000000001
R_2_13_2_1 Node2_13_2 Node2_13_3 2.5000000000000004
R_2_13_2_2 Node2_13_2 Node2_14_2 2.5000000000000004
R_2_13_2_3 Node2_13_2 GND 706560.0000000001
R_2_13_3_1 Node2_13_3 Node2_13_4 2.5000000000000004
R_2_13_3_2 Node2_13_3 Node2_14_3 2.5000000000000004
R_2_13_3_3 Node2_13_3 GND 706560.0000000001
R_2_13_4_1 Node2_13_4 Node2_13_5 2.5000000000000004
R_2_13_4_2 Node2_13_4 Node2_14_4 2.5000000000000004
R_2_13_4_3 Node2_13_4 GND 706560.0000000001
R_2_13_5_1 Node2_13_5 Node2_13_6 2.5000000000000004
R_2_13_5_2 Node2_13_5 Node2_14_5 2.5000000000000004
R_2_13_5_3 Node2_13_5 GND 706560.0000000001
R_2_13_6_1 Node2_13_6 Node2_13_7 2.5000000000000004
R_2_13_6_2 Node2_13_6 Node2_14_6 2.5000000000000004
R_2_13_6_3 Node2_13_6 GND 706560.0000000001
R_2_13_7_1 Node2_13_7 Node2_13_8 2.5000000000000004
R_2_13_7_2 Node2_13_7 Node2_14_7 2.5000000000000004
R_2_13_7_3 Node2_13_7 GND 706560.0000000001
R_2_13_8_1 Node2_13_8 Node2_13_9 2.5000000000000004
R_2_13_8_2 Node2_13_8 Node2_14_8 2.5000000000000004
R_2_13_8_3 Node2_13_8 GND 706560.0000000001
R_2_13_9_1 Node2_13_9 Node2_13_10 2.5000000000000004
R_2_13_9_2 Node2_13_9 Node2_14_9 2.5000000000000004
R_2_13_9_3 Node2_13_9 GND 706560.0000000001
R_2_13_10_1 Node2_13_10 Node2_13_11 2.5000000000000004
R_2_13_10_2 Node2_13_10 Node2_14_10 2.5000000000000004
R_2_13_10_3 Node2_13_10 GND 706560.0000000001
R_2_13_11_1 Node2_13_11 Node2_13_12 2.5000000000000004
R_2_13_11_2 Node2_13_11 Node2_14_11 2.5000000000000004
R_2_13_11_3 Node2_13_11 GND 706560.0000000001
R_2_13_12_1 Node2_13_12 Node2_13_13 2.5000000000000004
R_2_13_12_2 Node2_13_12 Node2_14_12 2.5000000000000004
R_2_13_12_3 Node2_13_12 GND 706560.0000000001
R_2_13_13_1 Node2_13_13 Node2_13_14 2.5000000000000004
R_2_13_13_2 Node2_13_13 Node2_14_13 2.5000000000000004
R_2_13_13_3 Node2_13_13 GND 706560.0000000001
R_2_13_14_1 Node2_13_14 Node2_13_15 2.5000000000000004
R_2_13_14_2 Node2_13_14 Node2_14_14 2.5000000000000004
R_2_13_14_3 Node2_13_14 GND 706560.0000000001
R_2_13_15_1 Node2_13_15 Node2_13_16 2.5000000000000004
R_2_13_15_2 Node2_13_15 Node2_14_15 2.5000000000000004
R_2_13_15_3 Node2_13_15 GND 706560.0000000001
R_2_13_16_1 Node2_13_16 Node2_13_17 2.5000000000000004
R_2_13_16_2 Node2_13_16 Node2_14_16 2.5000000000000004
R_2_13_16_3 Node2_13_16 GND 706560.0000000001
R_2_13_17_1 Node2_13_17 Node2_13_18 2.5000000000000004
R_2_13_17_2 Node2_13_17 Node2_14_17 2.5000000000000004
R_2_13_17_3 Node2_13_17 GND 706560.0000000001
R_2_13_18_1 Node2_13_18 Node2_13_19 2.5000000000000004
R_2_13_18_2 Node2_13_18 Node2_14_18 2.5000000000000004
R_2_13_18_3 Node2_13_18 GND 706560.0000000001
R_2_13_19_1 Node2_13_19 Node2_13_20 2.5000000000000004
R_2_13_19_2 Node2_13_19 Node2_14_19 2.5000000000000004
R_2_13_19_3 Node2_13_19 GND 706560.0000000001
R_2_13_20_1 Node2_13_20 Node2_13_21 2.5000000000000004
R_2_13_20_2 Node2_13_20 Node2_14_20 2.5000000000000004
R_2_13_20_3 Node2_13_20 GND 706560.0000000001
R_2_13_21_1 Node2_13_21 Node2_13_22 2.5000000000000004
R_2_13_21_2 Node2_13_21 Node2_14_21 2.5000000000000004
R_2_13_21_3 Node2_13_21 GND 706560.0000000001
R_2_13_22_1 Node2_13_22 Node2_13_23 2.5000000000000004
R_2_13_22_2 Node2_13_22 Node2_14_22 2.5000000000000004
R_2_13_22_3 Node2_13_22 GND 706560.0000000001
R_2_13_23_1 Node2_13_23 Node2_13_24 2.5000000000000004
R_2_13_23_2 Node2_13_23 Node2_14_23 2.5000000000000004
R_2_13_23_3 Node2_13_23 GND 706560.0000000001
R_2_13_24_1 Node2_13_24 Node2_13_25 2.5000000000000004
R_2_13_24_2 Node2_13_24 Node2_14_24 2.5000000000000004
R_2_13_24_3 Node2_13_24 GND 706560.0000000001
R_2_13_25_1 Node2_13_25 Node2_13_26 2.5000000000000004
R_2_13_25_2 Node2_13_25 Node2_14_25 2.5000000000000004
R_2_13_25_3 Node2_13_25 GND 706560.0000000001
R_2_13_26_1 Node2_13_26 Node2_13_27 2.5000000000000004
R_2_13_26_2 Node2_13_26 Node2_14_26 2.5000000000000004
R_2_13_26_3 Node2_13_26 GND 706560.0000000001
R_2_13_27_1 Node2_13_27 Node2_13_28 2.5000000000000004
R_2_13_27_2 Node2_13_27 Node2_14_27 2.5000000000000004
R_2_13_27_3 Node2_13_27 GND 706560.0000000001
R_2_13_28_1 Node2_13_28 Node2_13_29 2.5000000000000004
R_2_13_28_2 Node2_13_28 Node2_14_28 2.5000000000000004
R_2_13_28_3 Node2_13_28 GND 706560.0000000001
R_2_13_29_1 Node2_13_29 Node2_13_30 2.5000000000000004
R_2_13_29_2 Node2_13_29 Node2_14_29 2.5000000000000004
R_2_13_29_3 Node2_13_29 GND 706560.0000000001
R_2_13_30_1 Node2_13_30 Node2_13_31 2.5000000000000004
R_2_13_30_2 Node2_13_30 Node2_14_30 2.5000000000000004
R_2_13_30_3 Node2_13_30 GND 706560.0000000001
Rhs_2_13_31_1 Node2_13_31 Node_hs_right 71.54069767441861
R_2_13_31_2 Node2_13_31 Node2_14_31 2.5000000000000004
R_2_13_31_3 Node2_13_31 GND 706560.0000000001
R_2_14_0_1 Node2_14_0 Node2_14_1 2.5000000000000004
Rhs_2_14_0_1 Node2_14_0 Node_hs_right 71.54069767441861
R_2_14_0_2 Node2_14_0 Node2_15_0 2.5000000000000004
R_2_14_0_3 Node2_14_0 GND 706560.0000000001
R_2_14_1_1 Node2_14_1 Node2_14_2 2.5000000000000004
R_2_14_1_2 Node2_14_1 Node2_15_1 2.5000000000000004
R_2_14_1_3 Node2_14_1 GND 706560.0000000001
R_2_14_2_1 Node2_14_2 Node2_14_3 2.5000000000000004
R_2_14_2_2 Node2_14_2 Node2_15_2 2.5000000000000004
R_2_14_2_3 Node2_14_2 GND 706560.0000000001
R_2_14_3_1 Node2_14_3 Node2_14_4 2.5000000000000004
R_2_14_3_2 Node2_14_3 Node2_15_3 2.5000000000000004
R_2_14_3_3 Node2_14_3 GND 706560.0000000001
R_2_14_4_1 Node2_14_4 Node2_14_5 2.5000000000000004
R_2_14_4_2 Node2_14_4 Node2_15_4 2.5000000000000004
R_2_14_4_3 Node2_14_4 GND 706560.0000000001
R_2_14_5_1 Node2_14_5 Node2_14_6 2.5000000000000004
R_2_14_5_2 Node2_14_5 Node2_15_5 2.5000000000000004
R_2_14_5_3 Node2_14_5 GND 706560.0000000001
R_2_14_6_1 Node2_14_6 Node2_14_7 2.5000000000000004
R_2_14_6_2 Node2_14_6 Node2_15_6 2.5000000000000004
R_2_14_6_3 Node2_14_6 GND 706560.0000000001
R_2_14_7_1 Node2_14_7 Node2_14_8 2.5000000000000004
R_2_14_7_2 Node2_14_7 Node2_15_7 2.5000000000000004
R_2_14_7_3 Node2_14_7 GND 706560.0000000001
R_2_14_8_1 Node2_14_8 Node2_14_9 2.5000000000000004
R_2_14_8_2 Node2_14_8 Node2_15_8 2.5000000000000004
R_2_14_8_3 Node2_14_8 GND 706560.0000000001
R_2_14_9_1 Node2_14_9 Node2_14_10 2.5000000000000004
R_2_14_9_2 Node2_14_9 Node2_15_9 2.5000000000000004
R_2_14_9_3 Node2_14_9 GND 706560.0000000001
R_2_14_10_1 Node2_14_10 Node2_14_11 2.5000000000000004
R_2_14_10_2 Node2_14_10 Node2_15_10 2.5000000000000004
R_2_14_10_3 Node2_14_10 GND 706560.0000000001
R_2_14_11_1 Node2_14_11 Node2_14_12 2.5000000000000004
R_2_14_11_2 Node2_14_11 Node2_15_11 2.5000000000000004
R_2_14_11_3 Node2_14_11 GND 706560.0000000001
R_2_14_12_1 Node2_14_12 Node2_14_13 2.5000000000000004
R_2_14_12_2 Node2_14_12 Node2_15_12 2.5000000000000004
R_2_14_12_3 Node2_14_12 GND 706560.0000000001
R_2_14_13_1 Node2_14_13 Node2_14_14 2.5000000000000004
R_2_14_13_2 Node2_14_13 Node2_15_13 2.5000000000000004
R_2_14_13_3 Node2_14_13 GND 706560.0000000001
R_2_14_14_1 Node2_14_14 Node2_14_15 2.5000000000000004
R_2_14_14_2 Node2_14_14 Node2_15_14 2.5000000000000004
R_2_14_14_3 Node2_14_14 GND 706560.0000000001
R_2_14_15_1 Node2_14_15 Node2_14_16 2.5000000000000004
R_2_14_15_2 Node2_14_15 Node2_15_15 2.5000000000000004
R_2_14_15_3 Node2_14_15 GND 706560.0000000001
R_2_14_16_1 Node2_14_16 Node2_14_17 2.5000000000000004
R_2_14_16_2 Node2_14_16 Node2_15_16 2.5000000000000004
R_2_14_16_3 Node2_14_16 GND 706560.0000000001
R_2_14_17_1 Node2_14_17 Node2_14_18 2.5000000000000004
R_2_14_17_2 Node2_14_17 Node2_15_17 2.5000000000000004
R_2_14_17_3 Node2_14_17 GND 706560.0000000001
R_2_14_18_1 Node2_14_18 Node2_14_19 2.5000000000000004
R_2_14_18_2 Node2_14_18 Node2_15_18 2.5000000000000004
R_2_14_18_3 Node2_14_18 GND 706560.0000000001
R_2_14_19_1 Node2_14_19 Node2_14_20 2.5000000000000004
R_2_14_19_2 Node2_14_19 Node2_15_19 2.5000000000000004
R_2_14_19_3 Node2_14_19 GND 706560.0000000001
R_2_14_20_1 Node2_14_20 Node2_14_21 2.5000000000000004
R_2_14_20_2 Node2_14_20 Node2_15_20 2.5000000000000004
R_2_14_20_3 Node2_14_20 GND 706560.0000000001
R_2_14_21_1 Node2_14_21 Node2_14_22 2.5000000000000004
R_2_14_21_2 Node2_14_21 Node2_15_21 2.5000000000000004
R_2_14_21_3 Node2_14_21 GND 706560.0000000001
R_2_14_22_1 Node2_14_22 Node2_14_23 2.5000000000000004
R_2_14_22_2 Node2_14_22 Node2_15_22 2.5000000000000004
R_2_14_22_3 Node2_14_22 GND 706560.0000000001
R_2_14_23_1 Node2_14_23 Node2_14_24 2.5000000000000004
R_2_14_23_2 Node2_14_23 Node2_15_23 2.5000000000000004
R_2_14_23_3 Node2_14_23 GND 706560.0000000001
R_2_14_24_1 Node2_14_24 Node2_14_25 2.5000000000000004
R_2_14_24_2 Node2_14_24 Node2_15_24 2.5000000000000004
R_2_14_24_3 Node2_14_24 GND 706560.0000000001
R_2_14_25_1 Node2_14_25 Node2_14_26 2.5000000000000004
R_2_14_25_2 Node2_14_25 Node2_15_25 2.5000000000000004
R_2_14_25_3 Node2_14_25 GND 706560.0000000001
R_2_14_26_1 Node2_14_26 Node2_14_27 2.5000000000000004
R_2_14_26_2 Node2_14_26 Node2_15_26 2.5000000000000004
R_2_14_26_3 Node2_14_26 GND 706560.0000000001
R_2_14_27_1 Node2_14_27 Node2_14_28 2.5000000000000004
R_2_14_27_2 Node2_14_27 Node2_15_27 2.5000000000000004
R_2_14_27_3 Node2_14_27 GND 706560.0000000001
R_2_14_28_1 Node2_14_28 Node2_14_29 2.5000000000000004
R_2_14_28_2 Node2_14_28 Node2_15_28 2.5000000000000004
R_2_14_28_3 Node2_14_28 GND 706560.0000000001
R_2_14_29_1 Node2_14_29 Node2_14_30 2.5000000000000004
R_2_14_29_2 Node2_14_29 Node2_15_29 2.5000000000000004
R_2_14_29_3 Node2_14_29 GND 706560.0000000001
R_2_14_30_1 Node2_14_30 Node2_14_31 2.5000000000000004
R_2_14_30_2 Node2_14_30 Node2_15_30 2.5000000000000004
R_2_14_30_3 Node2_14_30 GND 706560.0000000001
Rhs_2_14_31_1 Node2_14_31 Node_hs_right 71.54069767441861
R_2_14_31_2 Node2_14_31 Node2_15_31 2.5000000000000004
R_2_14_31_3 Node2_14_31 GND 706560.0000000001
R_2_15_0_1 Node2_15_0 Node2_15_1 2.5000000000000004
Rhs_2_15_0_1 Node2_15_0 Node_hs_right 71.54069767441861
R_2_15_0_2 Node2_15_0 Node2_16_0 2.5000000000000004
R_2_15_0_3 Node2_15_0 GND 706560.0000000001
R_2_15_1_1 Node2_15_1 Node2_15_2 2.5000000000000004
R_2_15_1_2 Node2_15_1 Node2_16_1 2.5000000000000004
R_2_15_1_3 Node2_15_1 GND 706560.0000000001
R_2_15_2_1 Node2_15_2 Node2_15_3 2.5000000000000004
R_2_15_2_2 Node2_15_2 Node2_16_2 2.5000000000000004
R_2_15_2_3 Node2_15_2 GND 706560.0000000001
R_2_15_3_1 Node2_15_3 Node2_15_4 2.5000000000000004
R_2_15_3_2 Node2_15_3 Node2_16_3 2.5000000000000004
R_2_15_3_3 Node2_15_3 GND 706560.0000000001
R_2_15_4_1 Node2_15_4 Node2_15_5 2.5000000000000004
R_2_15_4_2 Node2_15_4 Node2_16_4 2.5000000000000004
R_2_15_4_3 Node2_15_4 GND 706560.0000000001
R_2_15_5_1 Node2_15_5 Node2_15_6 2.5000000000000004
R_2_15_5_2 Node2_15_5 Node2_16_5 2.5000000000000004
R_2_15_5_3 Node2_15_5 GND 706560.0000000001
R_2_15_6_1 Node2_15_6 Node2_15_7 2.5000000000000004
R_2_15_6_2 Node2_15_6 Node2_16_6 2.5000000000000004
R_2_15_6_3 Node2_15_6 GND 706560.0000000001
R_2_15_7_1 Node2_15_7 Node2_15_8 2.5000000000000004
R_2_15_7_2 Node2_15_7 Node2_16_7 2.5000000000000004
R_2_15_7_3 Node2_15_7 GND 706560.0000000001
R_2_15_8_1 Node2_15_8 Node2_15_9 2.5000000000000004
R_2_15_8_2 Node2_15_8 Node2_16_8 2.5000000000000004
R_2_15_8_3 Node2_15_8 GND 706560.0000000001
R_2_15_9_1 Node2_15_9 Node2_15_10 2.5000000000000004
R_2_15_9_2 Node2_15_9 Node2_16_9 2.5000000000000004
R_2_15_9_3 Node2_15_9 GND 706560.0000000001
R_2_15_10_1 Node2_15_10 Node2_15_11 2.5000000000000004
R_2_15_10_2 Node2_15_10 Node2_16_10 2.5000000000000004
R_2_15_10_3 Node2_15_10 GND 706560.0000000001
R_2_15_11_1 Node2_15_11 Node2_15_12 2.5000000000000004
R_2_15_11_2 Node2_15_11 Node2_16_11 2.5000000000000004
R_2_15_11_3 Node2_15_11 GND 706560.0000000001
R_2_15_12_1 Node2_15_12 Node2_15_13 2.5000000000000004
R_2_15_12_2 Node2_15_12 Node2_16_12 2.5000000000000004
R_2_15_12_3 Node2_15_12 GND 706560.0000000001
R_2_15_13_1 Node2_15_13 Node2_15_14 2.5000000000000004
R_2_15_13_2 Node2_15_13 Node2_16_13 2.5000000000000004
R_2_15_13_3 Node2_15_13 GND 706560.0000000001
R_2_15_14_1 Node2_15_14 Node2_15_15 2.5000000000000004
R_2_15_14_2 Node2_15_14 Node2_16_14 2.5000000000000004
R_2_15_14_3 Node2_15_14 GND 706560.0000000001
R_2_15_15_1 Node2_15_15 Node2_15_16 2.5000000000000004
R_2_15_15_2 Node2_15_15 Node2_16_15 2.5000000000000004
R_2_15_15_3 Node2_15_15 GND 706560.0000000001
R_2_15_16_1 Node2_15_16 Node2_15_17 2.5000000000000004
R_2_15_16_2 Node2_15_16 Node2_16_16 2.5000000000000004
R_2_15_16_3 Node2_15_16 GND 706560.0000000001
R_2_15_17_1 Node2_15_17 Node2_15_18 2.5000000000000004
R_2_15_17_2 Node2_15_17 Node2_16_17 2.5000000000000004
R_2_15_17_3 Node2_15_17 GND 706560.0000000001
R_2_15_18_1 Node2_15_18 Node2_15_19 2.5000000000000004
R_2_15_18_2 Node2_15_18 Node2_16_18 2.5000000000000004
R_2_15_18_3 Node2_15_18 GND 706560.0000000001
R_2_15_19_1 Node2_15_19 Node2_15_20 2.5000000000000004
R_2_15_19_2 Node2_15_19 Node2_16_19 2.5000000000000004
R_2_15_19_3 Node2_15_19 GND 706560.0000000001
R_2_15_20_1 Node2_15_20 Node2_15_21 2.5000000000000004
R_2_15_20_2 Node2_15_20 Node2_16_20 2.5000000000000004
R_2_15_20_3 Node2_15_20 GND 706560.0000000001
R_2_15_21_1 Node2_15_21 Node2_15_22 2.5000000000000004
R_2_15_21_2 Node2_15_21 Node2_16_21 2.5000000000000004
R_2_15_21_3 Node2_15_21 GND 706560.0000000001
R_2_15_22_1 Node2_15_22 Node2_15_23 2.5000000000000004
R_2_15_22_2 Node2_15_22 Node2_16_22 2.5000000000000004
R_2_15_22_3 Node2_15_22 GND 706560.0000000001
R_2_15_23_1 Node2_15_23 Node2_15_24 2.5000000000000004
R_2_15_23_2 Node2_15_23 Node2_16_23 2.5000000000000004
R_2_15_23_3 Node2_15_23 GND 706560.0000000001
R_2_15_24_1 Node2_15_24 Node2_15_25 2.5000000000000004
R_2_15_24_2 Node2_15_24 Node2_16_24 2.5000000000000004
R_2_15_24_3 Node2_15_24 GND 706560.0000000001
R_2_15_25_1 Node2_15_25 Node2_15_26 2.5000000000000004
R_2_15_25_2 Node2_15_25 Node2_16_25 2.5000000000000004
R_2_15_25_3 Node2_15_25 GND 706560.0000000001
R_2_15_26_1 Node2_15_26 Node2_15_27 2.5000000000000004
R_2_15_26_2 Node2_15_26 Node2_16_26 2.5000000000000004
R_2_15_26_3 Node2_15_26 GND 706560.0000000001
R_2_15_27_1 Node2_15_27 Node2_15_28 2.5000000000000004
R_2_15_27_2 Node2_15_27 Node2_16_27 2.5000000000000004
R_2_15_27_3 Node2_15_27 GND 706560.0000000001
R_2_15_28_1 Node2_15_28 Node2_15_29 2.5000000000000004
R_2_15_28_2 Node2_15_28 Node2_16_28 2.5000000000000004
R_2_15_28_3 Node2_15_28 GND 706560.0000000001
R_2_15_29_1 Node2_15_29 Node2_15_30 2.5000000000000004
R_2_15_29_2 Node2_15_29 Node2_16_29 2.5000000000000004
R_2_15_29_3 Node2_15_29 GND 706560.0000000001
R_2_15_30_1 Node2_15_30 Node2_15_31 2.5000000000000004
R_2_15_30_2 Node2_15_30 Node2_16_30 2.5000000000000004
R_2_15_30_3 Node2_15_30 GND 706560.0000000001
Rhs_2_15_31_1 Node2_15_31 Node_hs_right 71.54069767441861
R_2_15_31_2 Node2_15_31 Node2_16_31 2.5000000000000004
R_2_15_31_3 Node2_15_31 GND 706560.0000000001
R_2_16_0_1 Node2_16_0 Node2_16_1 2.5000000000000004
Rhs_2_16_0_1 Node2_16_0 Node_hs_right 71.54069767441861
R_2_16_0_2 Node2_16_0 Node2_17_0 2.5000000000000004
R_2_16_0_3 Node2_16_0 GND 706560.0000000001
R_2_16_1_1 Node2_16_1 Node2_16_2 2.5000000000000004
R_2_16_1_2 Node2_16_1 Node2_17_1 2.5000000000000004
R_2_16_1_3 Node2_16_1 GND 706560.0000000001
R_2_16_2_1 Node2_16_2 Node2_16_3 2.5000000000000004
R_2_16_2_2 Node2_16_2 Node2_17_2 2.5000000000000004
R_2_16_2_3 Node2_16_2 GND 706560.0000000001
R_2_16_3_1 Node2_16_3 Node2_16_4 2.5000000000000004
R_2_16_3_2 Node2_16_3 Node2_17_3 2.5000000000000004
R_2_16_3_3 Node2_16_3 GND 706560.0000000001
R_2_16_4_1 Node2_16_4 Node2_16_5 2.5000000000000004
R_2_16_4_2 Node2_16_4 Node2_17_4 2.5000000000000004
R_2_16_4_3 Node2_16_4 GND 706560.0000000001
R_2_16_5_1 Node2_16_5 Node2_16_6 2.5000000000000004
R_2_16_5_2 Node2_16_5 Node2_17_5 2.5000000000000004
R_2_16_5_3 Node2_16_5 GND 706560.0000000001
R_2_16_6_1 Node2_16_6 Node2_16_7 2.5000000000000004
R_2_16_6_2 Node2_16_6 Node2_17_6 2.5000000000000004
R_2_16_6_3 Node2_16_6 GND 706560.0000000001
R_2_16_7_1 Node2_16_7 Node2_16_8 2.5000000000000004
R_2_16_7_2 Node2_16_7 Node2_17_7 2.5000000000000004
R_2_16_7_3 Node2_16_7 GND 706560.0000000001
R_2_16_8_1 Node2_16_8 Node2_16_9 2.5000000000000004
R_2_16_8_2 Node2_16_8 Node2_17_8 2.5000000000000004
R_2_16_8_3 Node2_16_8 GND 706560.0000000001
R_2_16_9_1 Node2_16_9 Node2_16_10 2.5000000000000004
R_2_16_9_2 Node2_16_9 Node2_17_9 2.5000000000000004
R_2_16_9_3 Node2_16_9 GND 706560.0000000001
R_2_16_10_1 Node2_16_10 Node2_16_11 2.5000000000000004
R_2_16_10_2 Node2_16_10 Node2_17_10 2.5000000000000004
R_2_16_10_3 Node2_16_10 GND 706560.0000000001
R_2_16_11_1 Node2_16_11 Node2_16_12 2.5000000000000004
R_2_16_11_2 Node2_16_11 Node2_17_11 2.5000000000000004
R_2_16_11_3 Node2_16_11 GND 706560.0000000001
R_2_16_12_1 Node2_16_12 Node2_16_13 2.5000000000000004
R_2_16_12_2 Node2_16_12 Node2_17_12 2.5000000000000004
R_2_16_12_3 Node2_16_12 GND 706560.0000000001
R_2_16_13_1 Node2_16_13 Node2_16_14 2.5000000000000004
R_2_16_13_2 Node2_16_13 Node2_17_13 2.5000000000000004
R_2_16_13_3 Node2_16_13 GND 706560.0000000001
R_2_16_14_1 Node2_16_14 Node2_16_15 2.5000000000000004
R_2_16_14_2 Node2_16_14 Node2_17_14 2.5000000000000004
R_2_16_14_3 Node2_16_14 GND 706560.0000000001
R_2_16_15_1 Node2_16_15 Node2_16_16 2.5000000000000004
R_2_16_15_2 Node2_16_15 Node2_17_15 2.5000000000000004
R_2_16_15_3 Node2_16_15 GND 706560.0000000001
R_2_16_16_1 Node2_16_16 Node2_16_17 2.5000000000000004
R_2_16_16_2 Node2_16_16 Node2_17_16 2.5000000000000004
R_2_16_16_3 Node2_16_16 GND 706560.0000000001
R_2_16_17_1 Node2_16_17 Node2_16_18 2.5000000000000004
R_2_16_17_2 Node2_16_17 Node2_17_17 2.5000000000000004
R_2_16_17_3 Node2_16_17 GND 706560.0000000001
R_2_16_18_1 Node2_16_18 Node2_16_19 2.5000000000000004
R_2_16_18_2 Node2_16_18 Node2_17_18 2.5000000000000004
R_2_16_18_3 Node2_16_18 GND 706560.0000000001
R_2_16_19_1 Node2_16_19 Node2_16_20 2.5000000000000004
R_2_16_19_2 Node2_16_19 Node2_17_19 2.5000000000000004
R_2_16_19_3 Node2_16_19 GND 706560.0000000001
R_2_16_20_1 Node2_16_20 Node2_16_21 2.5000000000000004
R_2_16_20_2 Node2_16_20 Node2_17_20 2.5000000000000004
R_2_16_20_3 Node2_16_20 GND 706560.0000000001
R_2_16_21_1 Node2_16_21 Node2_16_22 2.5000000000000004
R_2_16_21_2 Node2_16_21 Node2_17_21 2.5000000000000004
R_2_16_21_3 Node2_16_21 GND 706560.0000000001
R_2_16_22_1 Node2_16_22 Node2_16_23 2.5000000000000004
R_2_16_22_2 Node2_16_22 Node2_17_22 2.5000000000000004
R_2_16_22_3 Node2_16_22 GND 706560.0000000001
R_2_16_23_1 Node2_16_23 Node2_16_24 2.5000000000000004
R_2_16_23_2 Node2_16_23 Node2_17_23 2.5000000000000004
R_2_16_23_3 Node2_16_23 GND 706560.0000000001
R_2_16_24_1 Node2_16_24 Node2_16_25 2.5000000000000004
R_2_16_24_2 Node2_16_24 Node2_17_24 2.5000000000000004
R_2_16_24_3 Node2_16_24 GND 706560.0000000001
R_2_16_25_1 Node2_16_25 Node2_16_26 2.5000000000000004
R_2_16_25_2 Node2_16_25 Node2_17_25 2.5000000000000004
R_2_16_25_3 Node2_16_25 GND 706560.0000000001
R_2_16_26_1 Node2_16_26 Node2_16_27 2.5000000000000004
R_2_16_26_2 Node2_16_26 Node2_17_26 2.5000000000000004
R_2_16_26_3 Node2_16_26 GND 706560.0000000001
R_2_16_27_1 Node2_16_27 Node2_16_28 2.5000000000000004
R_2_16_27_2 Node2_16_27 Node2_17_27 2.5000000000000004
R_2_16_27_3 Node2_16_27 GND 706560.0000000001
R_2_16_28_1 Node2_16_28 Node2_16_29 2.5000000000000004
R_2_16_28_2 Node2_16_28 Node2_17_28 2.5000000000000004
R_2_16_28_3 Node2_16_28 GND 706560.0000000001
R_2_16_29_1 Node2_16_29 Node2_16_30 2.5000000000000004
R_2_16_29_2 Node2_16_29 Node2_17_29 2.5000000000000004
R_2_16_29_3 Node2_16_29 GND 706560.0000000001
R_2_16_30_1 Node2_16_30 Node2_16_31 2.5000000000000004
R_2_16_30_2 Node2_16_30 Node2_17_30 2.5000000000000004
R_2_16_30_3 Node2_16_30 GND 706560.0000000001
Rhs_2_16_31_1 Node2_16_31 Node_hs_right 71.54069767441861
R_2_16_31_2 Node2_16_31 Node2_17_31 2.5000000000000004
R_2_16_31_3 Node2_16_31 GND 706560.0000000001
R_2_17_0_1 Node2_17_0 Node2_17_1 2.5000000000000004
Rhs_2_17_0_1 Node2_17_0 Node_hs_right 71.54069767441861
R_2_17_0_2 Node2_17_0 Node2_18_0 2.5000000000000004
R_2_17_0_3 Node2_17_0 GND 706560.0000000001
R_2_17_1_1 Node2_17_1 Node2_17_2 2.5000000000000004
R_2_17_1_2 Node2_17_1 Node2_18_1 2.5000000000000004
R_2_17_1_3 Node2_17_1 GND 706560.0000000001
R_2_17_2_1 Node2_17_2 Node2_17_3 2.5000000000000004
R_2_17_2_2 Node2_17_2 Node2_18_2 2.5000000000000004
R_2_17_2_3 Node2_17_2 GND 706560.0000000001
R_2_17_3_1 Node2_17_3 Node2_17_4 2.5000000000000004
R_2_17_3_2 Node2_17_3 Node2_18_3 2.5000000000000004
R_2_17_3_3 Node2_17_3 GND 706560.0000000001
R_2_17_4_1 Node2_17_4 Node2_17_5 2.5000000000000004
R_2_17_4_2 Node2_17_4 Node2_18_4 2.5000000000000004
R_2_17_4_3 Node2_17_4 GND 706560.0000000001
R_2_17_5_1 Node2_17_5 Node2_17_6 2.5000000000000004
R_2_17_5_2 Node2_17_5 Node2_18_5 2.5000000000000004
R_2_17_5_3 Node2_17_5 GND 706560.0000000001
R_2_17_6_1 Node2_17_6 Node2_17_7 2.5000000000000004
R_2_17_6_2 Node2_17_6 Node2_18_6 2.5000000000000004
R_2_17_6_3 Node2_17_6 GND 706560.0000000001
R_2_17_7_1 Node2_17_7 Node2_17_8 2.5000000000000004
R_2_17_7_2 Node2_17_7 Node2_18_7 2.5000000000000004
R_2_17_7_3 Node2_17_7 GND 706560.0000000001
R_2_17_8_1 Node2_17_8 Node2_17_9 2.5000000000000004
R_2_17_8_2 Node2_17_8 Node2_18_8 2.5000000000000004
R_2_17_8_3 Node2_17_8 GND 706560.0000000001
R_2_17_9_1 Node2_17_9 Node2_17_10 2.5000000000000004
R_2_17_9_2 Node2_17_9 Node2_18_9 2.5000000000000004
R_2_17_9_3 Node2_17_9 GND 706560.0000000001
R_2_17_10_1 Node2_17_10 Node2_17_11 2.5000000000000004
R_2_17_10_2 Node2_17_10 Node2_18_10 2.5000000000000004
R_2_17_10_3 Node2_17_10 GND 706560.0000000001
R_2_17_11_1 Node2_17_11 Node2_17_12 2.5000000000000004
R_2_17_11_2 Node2_17_11 Node2_18_11 2.5000000000000004
R_2_17_11_3 Node2_17_11 GND 706560.0000000001
R_2_17_12_1 Node2_17_12 Node2_17_13 2.5000000000000004
R_2_17_12_2 Node2_17_12 Node2_18_12 2.5000000000000004
R_2_17_12_3 Node2_17_12 GND 706560.0000000001
R_2_17_13_1 Node2_17_13 Node2_17_14 2.5000000000000004
R_2_17_13_2 Node2_17_13 Node2_18_13 2.5000000000000004
R_2_17_13_3 Node2_17_13 GND 706560.0000000001
R_2_17_14_1 Node2_17_14 Node2_17_15 2.5000000000000004
R_2_17_14_2 Node2_17_14 Node2_18_14 2.5000000000000004
R_2_17_14_3 Node2_17_14 GND 706560.0000000001
R_2_17_15_1 Node2_17_15 Node2_17_16 2.5000000000000004
R_2_17_15_2 Node2_17_15 Node2_18_15 2.5000000000000004
R_2_17_15_3 Node2_17_15 GND 706560.0000000001
R_2_17_16_1 Node2_17_16 Node2_17_17 2.5000000000000004
R_2_17_16_2 Node2_17_16 Node2_18_16 2.5000000000000004
R_2_17_16_3 Node2_17_16 GND 706560.0000000001
R_2_17_17_1 Node2_17_17 Node2_17_18 2.5000000000000004
R_2_17_17_2 Node2_17_17 Node2_18_17 2.5000000000000004
R_2_17_17_3 Node2_17_17 GND 706560.0000000001
R_2_17_18_1 Node2_17_18 Node2_17_19 2.5000000000000004
R_2_17_18_2 Node2_17_18 Node2_18_18 2.5000000000000004
R_2_17_18_3 Node2_17_18 GND 706560.0000000001
R_2_17_19_1 Node2_17_19 Node2_17_20 2.5000000000000004
R_2_17_19_2 Node2_17_19 Node2_18_19 2.5000000000000004
R_2_17_19_3 Node2_17_19 GND 706560.0000000001
R_2_17_20_1 Node2_17_20 Node2_17_21 2.5000000000000004
R_2_17_20_2 Node2_17_20 Node2_18_20 2.5000000000000004
R_2_17_20_3 Node2_17_20 GND 706560.0000000001
R_2_17_21_1 Node2_17_21 Node2_17_22 2.5000000000000004
R_2_17_21_2 Node2_17_21 Node2_18_21 2.5000000000000004
R_2_17_21_3 Node2_17_21 GND 706560.0000000001
R_2_17_22_1 Node2_17_22 Node2_17_23 2.5000000000000004
R_2_17_22_2 Node2_17_22 Node2_18_22 2.5000000000000004
R_2_17_22_3 Node2_17_22 GND 706560.0000000001
R_2_17_23_1 Node2_17_23 Node2_17_24 2.5000000000000004
R_2_17_23_2 Node2_17_23 Node2_18_23 2.5000000000000004
R_2_17_23_3 Node2_17_23 GND 706560.0000000001
R_2_17_24_1 Node2_17_24 Node2_17_25 2.5000000000000004
R_2_17_24_2 Node2_17_24 Node2_18_24 2.5000000000000004
R_2_17_24_3 Node2_17_24 GND 706560.0000000001
R_2_17_25_1 Node2_17_25 Node2_17_26 2.5000000000000004
R_2_17_25_2 Node2_17_25 Node2_18_25 2.5000000000000004
R_2_17_25_3 Node2_17_25 GND 706560.0000000001
R_2_17_26_1 Node2_17_26 Node2_17_27 2.5000000000000004
R_2_17_26_2 Node2_17_26 Node2_18_26 2.5000000000000004
R_2_17_26_3 Node2_17_26 GND 706560.0000000001
R_2_17_27_1 Node2_17_27 Node2_17_28 2.5000000000000004
R_2_17_27_2 Node2_17_27 Node2_18_27 2.5000000000000004
R_2_17_27_3 Node2_17_27 GND 706560.0000000001
R_2_17_28_1 Node2_17_28 Node2_17_29 2.5000000000000004
R_2_17_28_2 Node2_17_28 Node2_18_28 2.5000000000000004
R_2_17_28_3 Node2_17_28 GND 706560.0000000001
R_2_17_29_1 Node2_17_29 Node2_17_30 2.5000000000000004
R_2_17_29_2 Node2_17_29 Node2_18_29 2.5000000000000004
R_2_17_29_3 Node2_17_29 GND 706560.0000000001
R_2_17_30_1 Node2_17_30 Node2_17_31 2.5000000000000004
R_2_17_30_2 Node2_17_30 Node2_18_30 2.5000000000000004
R_2_17_30_3 Node2_17_30 GND 706560.0000000001
Rhs_2_17_31_1 Node2_17_31 Node_hs_right 71.54069767441861
R_2_17_31_2 Node2_17_31 Node2_18_31 2.5000000000000004
R_2_17_31_3 Node2_17_31 GND 706560.0000000001
R_2_18_0_1 Node2_18_0 Node2_18_1 2.5000000000000004
Rhs_2_18_0_1 Node2_18_0 Node_hs_right 71.54069767441861
R_2_18_0_2 Node2_18_0 Node2_19_0 2.5000000000000004
R_2_18_0_3 Node2_18_0 GND 706560.0000000001
R_2_18_1_1 Node2_18_1 Node2_18_2 2.5000000000000004
R_2_18_1_2 Node2_18_1 Node2_19_1 2.5000000000000004
R_2_18_1_3 Node2_18_1 GND 706560.0000000001
R_2_18_2_1 Node2_18_2 Node2_18_3 2.5000000000000004
R_2_18_2_2 Node2_18_2 Node2_19_2 2.5000000000000004
R_2_18_2_3 Node2_18_2 GND 706560.0000000001
R_2_18_3_1 Node2_18_3 Node2_18_4 2.5000000000000004
R_2_18_3_2 Node2_18_3 Node2_19_3 2.5000000000000004
R_2_18_3_3 Node2_18_3 GND 706560.0000000001
R_2_18_4_1 Node2_18_4 Node2_18_5 2.5000000000000004
R_2_18_4_2 Node2_18_4 Node2_19_4 2.5000000000000004
R_2_18_4_3 Node2_18_4 GND 706560.0000000001
R_2_18_5_1 Node2_18_5 Node2_18_6 2.5000000000000004
R_2_18_5_2 Node2_18_5 Node2_19_5 2.5000000000000004
R_2_18_5_3 Node2_18_5 GND 706560.0000000001
R_2_18_6_1 Node2_18_6 Node2_18_7 2.5000000000000004
R_2_18_6_2 Node2_18_6 Node2_19_6 2.5000000000000004
R_2_18_6_3 Node2_18_6 GND 706560.0000000001
R_2_18_7_1 Node2_18_7 Node2_18_8 2.5000000000000004
R_2_18_7_2 Node2_18_7 Node2_19_7 2.5000000000000004
R_2_18_7_3 Node2_18_7 GND 706560.0000000001
R_2_18_8_1 Node2_18_8 Node2_18_9 2.5000000000000004
R_2_18_8_2 Node2_18_8 Node2_19_8 2.5000000000000004
R_2_18_8_3 Node2_18_8 GND 706560.0000000001
R_2_18_9_1 Node2_18_9 Node2_18_10 2.5000000000000004
R_2_18_9_2 Node2_18_9 Node2_19_9 2.5000000000000004
R_2_18_9_3 Node2_18_9 GND 706560.0000000001
R_2_18_10_1 Node2_18_10 Node2_18_11 2.5000000000000004
R_2_18_10_2 Node2_18_10 Node2_19_10 2.5000000000000004
R_2_18_10_3 Node2_18_10 GND 706560.0000000001
R_2_18_11_1 Node2_18_11 Node2_18_12 2.5000000000000004
R_2_18_11_2 Node2_18_11 Node2_19_11 2.5000000000000004
R_2_18_11_3 Node2_18_11 GND 706560.0000000001
R_2_18_12_1 Node2_18_12 Node2_18_13 2.5000000000000004
R_2_18_12_2 Node2_18_12 Node2_19_12 2.5000000000000004
R_2_18_12_3 Node2_18_12 GND 706560.0000000001
R_2_18_13_1 Node2_18_13 Node2_18_14 2.5000000000000004
R_2_18_13_2 Node2_18_13 Node2_19_13 2.5000000000000004
R_2_18_13_3 Node2_18_13 GND 706560.0000000001
R_2_18_14_1 Node2_18_14 Node2_18_15 2.5000000000000004
R_2_18_14_2 Node2_18_14 Node2_19_14 2.5000000000000004
R_2_18_14_3 Node2_18_14 GND 706560.0000000001
R_2_18_15_1 Node2_18_15 Node2_18_16 2.5000000000000004
R_2_18_15_2 Node2_18_15 Node2_19_15 2.5000000000000004
R_2_18_15_3 Node2_18_15 GND 706560.0000000001
R_2_18_16_1 Node2_18_16 Node2_18_17 2.5000000000000004
R_2_18_16_2 Node2_18_16 Node2_19_16 2.5000000000000004
R_2_18_16_3 Node2_18_16 GND 706560.0000000001
R_2_18_17_1 Node2_18_17 Node2_18_18 2.5000000000000004
R_2_18_17_2 Node2_18_17 Node2_19_17 2.5000000000000004
R_2_18_17_3 Node2_18_17 GND 706560.0000000001
R_2_18_18_1 Node2_18_18 Node2_18_19 2.5000000000000004
R_2_18_18_2 Node2_18_18 Node2_19_18 2.5000000000000004
R_2_18_18_3 Node2_18_18 GND 706560.0000000001
R_2_18_19_1 Node2_18_19 Node2_18_20 2.5000000000000004
R_2_18_19_2 Node2_18_19 Node2_19_19 2.5000000000000004
R_2_18_19_3 Node2_18_19 GND 706560.0000000001
R_2_18_20_1 Node2_18_20 Node2_18_21 2.5000000000000004
R_2_18_20_2 Node2_18_20 Node2_19_20 2.5000000000000004
R_2_18_20_3 Node2_18_20 GND 706560.0000000001
R_2_18_21_1 Node2_18_21 Node2_18_22 2.5000000000000004
R_2_18_21_2 Node2_18_21 Node2_19_21 2.5000000000000004
R_2_18_21_3 Node2_18_21 GND 706560.0000000001
R_2_18_22_1 Node2_18_22 Node2_18_23 2.5000000000000004
R_2_18_22_2 Node2_18_22 Node2_19_22 2.5000000000000004
R_2_18_22_3 Node2_18_22 GND 706560.0000000001
R_2_18_23_1 Node2_18_23 Node2_18_24 2.5000000000000004
R_2_18_23_2 Node2_18_23 Node2_19_23 2.5000000000000004
R_2_18_23_3 Node2_18_23 GND 706560.0000000001
R_2_18_24_1 Node2_18_24 Node2_18_25 2.5000000000000004
R_2_18_24_2 Node2_18_24 Node2_19_24 2.5000000000000004
R_2_18_24_3 Node2_18_24 GND 706560.0000000001
R_2_18_25_1 Node2_18_25 Node2_18_26 2.5000000000000004
R_2_18_25_2 Node2_18_25 Node2_19_25 2.5000000000000004
R_2_18_25_3 Node2_18_25 GND 706560.0000000001
R_2_18_26_1 Node2_18_26 Node2_18_27 2.5000000000000004
R_2_18_26_2 Node2_18_26 Node2_19_26 2.5000000000000004
R_2_18_26_3 Node2_18_26 GND 706560.0000000001
R_2_18_27_1 Node2_18_27 Node2_18_28 2.5000000000000004
R_2_18_27_2 Node2_18_27 Node2_19_27 2.5000000000000004
R_2_18_27_3 Node2_18_27 GND 706560.0000000001
R_2_18_28_1 Node2_18_28 Node2_18_29 2.5000000000000004
R_2_18_28_2 Node2_18_28 Node2_19_28 2.5000000000000004
R_2_18_28_3 Node2_18_28 GND 706560.0000000001
R_2_18_29_1 Node2_18_29 Node2_18_30 2.5000000000000004
R_2_18_29_2 Node2_18_29 Node2_19_29 2.5000000000000004
R_2_18_29_3 Node2_18_29 GND 706560.0000000001
R_2_18_30_1 Node2_18_30 Node2_18_31 2.5000000000000004
R_2_18_30_2 Node2_18_30 Node2_19_30 2.5000000000000004
R_2_18_30_3 Node2_18_30 GND 706560.0000000001
Rhs_2_18_31_1 Node2_18_31 Node_hs_right 71.54069767441861
R_2_18_31_2 Node2_18_31 Node2_19_31 2.5000000000000004
R_2_18_31_3 Node2_18_31 GND 706560.0000000001
R_2_19_0_1 Node2_19_0 Node2_19_1 2.5000000000000004
Rhs_2_19_0_1 Node2_19_0 Node_hs_right 71.54069767441861
R_2_19_0_2 Node2_19_0 Node2_20_0 2.5000000000000004
R_2_19_0_3 Node2_19_0 GND 706560.0000000001
R_2_19_1_1 Node2_19_1 Node2_19_2 2.5000000000000004
R_2_19_1_2 Node2_19_1 Node2_20_1 2.5000000000000004
R_2_19_1_3 Node2_19_1 GND 706560.0000000001
R_2_19_2_1 Node2_19_2 Node2_19_3 2.5000000000000004
R_2_19_2_2 Node2_19_2 Node2_20_2 2.5000000000000004
R_2_19_2_3 Node2_19_2 GND 706560.0000000001
R_2_19_3_1 Node2_19_3 Node2_19_4 2.5000000000000004
R_2_19_3_2 Node2_19_3 Node2_20_3 2.5000000000000004
R_2_19_3_3 Node2_19_3 GND 706560.0000000001
R_2_19_4_1 Node2_19_4 Node2_19_5 2.5000000000000004
R_2_19_4_2 Node2_19_4 Node2_20_4 2.5000000000000004
R_2_19_4_3 Node2_19_4 GND 706560.0000000001
R_2_19_5_1 Node2_19_5 Node2_19_6 2.5000000000000004
R_2_19_5_2 Node2_19_5 Node2_20_5 2.5000000000000004
R_2_19_5_3 Node2_19_5 GND 706560.0000000001
R_2_19_6_1 Node2_19_6 Node2_19_7 2.5000000000000004
R_2_19_6_2 Node2_19_6 Node2_20_6 2.5000000000000004
R_2_19_6_3 Node2_19_6 GND 706560.0000000001
R_2_19_7_1 Node2_19_7 Node2_19_8 2.5000000000000004
R_2_19_7_2 Node2_19_7 Node2_20_7 2.5000000000000004
R_2_19_7_3 Node2_19_7 GND 706560.0000000001
R_2_19_8_1 Node2_19_8 Node2_19_9 2.5000000000000004
R_2_19_8_2 Node2_19_8 Node2_20_8 2.5000000000000004
R_2_19_8_3 Node2_19_8 GND 706560.0000000001
R_2_19_9_1 Node2_19_9 Node2_19_10 2.5000000000000004
R_2_19_9_2 Node2_19_9 Node2_20_9 2.5000000000000004
R_2_19_9_3 Node2_19_9 GND 706560.0000000001
R_2_19_10_1 Node2_19_10 Node2_19_11 2.5000000000000004
R_2_19_10_2 Node2_19_10 Node2_20_10 2.5000000000000004
R_2_19_10_3 Node2_19_10 GND 706560.0000000001
R_2_19_11_1 Node2_19_11 Node2_19_12 2.5000000000000004
R_2_19_11_2 Node2_19_11 Node2_20_11 2.5000000000000004
R_2_19_11_3 Node2_19_11 GND 706560.0000000001
R_2_19_12_1 Node2_19_12 Node2_19_13 2.5000000000000004
R_2_19_12_2 Node2_19_12 Node2_20_12 2.5000000000000004
R_2_19_12_3 Node2_19_12 GND 706560.0000000001
R_2_19_13_1 Node2_19_13 Node2_19_14 2.5000000000000004
R_2_19_13_2 Node2_19_13 Node2_20_13 2.5000000000000004
R_2_19_13_3 Node2_19_13 GND 706560.0000000001
R_2_19_14_1 Node2_19_14 Node2_19_15 2.5000000000000004
R_2_19_14_2 Node2_19_14 Node2_20_14 2.5000000000000004
R_2_19_14_3 Node2_19_14 GND 706560.0000000001
R_2_19_15_1 Node2_19_15 Node2_19_16 2.5000000000000004
R_2_19_15_2 Node2_19_15 Node2_20_15 2.5000000000000004
R_2_19_15_3 Node2_19_15 GND 706560.0000000001
R_2_19_16_1 Node2_19_16 Node2_19_17 2.5000000000000004
R_2_19_16_2 Node2_19_16 Node2_20_16 2.5000000000000004
R_2_19_16_3 Node2_19_16 GND 706560.0000000001
R_2_19_17_1 Node2_19_17 Node2_19_18 2.5000000000000004
R_2_19_17_2 Node2_19_17 Node2_20_17 2.5000000000000004
R_2_19_17_3 Node2_19_17 GND 706560.0000000001
R_2_19_18_1 Node2_19_18 Node2_19_19 2.5000000000000004
R_2_19_18_2 Node2_19_18 Node2_20_18 2.5000000000000004
R_2_19_18_3 Node2_19_18 GND 706560.0000000001
R_2_19_19_1 Node2_19_19 Node2_19_20 2.5000000000000004
R_2_19_19_2 Node2_19_19 Node2_20_19 2.5000000000000004
R_2_19_19_3 Node2_19_19 GND 706560.0000000001
R_2_19_20_1 Node2_19_20 Node2_19_21 2.5000000000000004
R_2_19_20_2 Node2_19_20 Node2_20_20 2.5000000000000004
R_2_19_20_3 Node2_19_20 GND 706560.0000000001
R_2_19_21_1 Node2_19_21 Node2_19_22 2.5000000000000004
R_2_19_21_2 Node2_19_21 Node2_20_21 2.5000000000000004
R_2_19_21_3 Node2_19_21 GND 706560.0000000001
R_2_19_22_1 Node2_19_22 Node2_19_23 2.5000000000000004
R_2_19_22_2 Node2_19_22 Node2_20_22 2.5000000000000004
R_2_19_22_3 Node2_19_22 GND 706560.0000000001
R_2_19_23_1 Node2_19_23 Node2_19_24 2.5000000000000004
R_2_19_23_2 Node2_19_23 Node2_20_23 2.5000000000000004
R_2_19_23_3 Node2_19_23 GND 706560.0000000001
R_2_19_24_1 Node2_19_24 Node2_19_25 2.5000000000000004
R_2_19_24_2 Node2_19_24 Node2_20_24 2.5000000000000004
R_2_19_24_3 Node2_19_24 GND 706560.0000000001
R_2_19_25_1 Node2_19_25 Node2_19_26 2.5000000000000004
R_2_19_25_2 Node2_19_25 Node2_20_25 2.5000000000000004
R_2_19_25_3 Node2_19_25 GND 706560.0000000001
R_2_19_26_1 Node2_19_26 Node2_19_27 2.5000000000000004
R_2_19_26_2 Node2_19_26 Node2_20_26 2.5000000000000004
R_2_19_26_3 Node2_19_26 GND 706560.0000000001
R_2_19_27_1 Node2_19_27 Node2_19_28 2.5000000000000004
R_2_19_27_2 Node2_19_27 Node2_20_27 2.5000000000000004
R_2_19_27_3 Node2_19_27 GND 706560.0000000001
R_2_19_28_1 Node2_19_28 Node2_19_29 2.5000000000000004
R_2_19_28_2 Node2_19_28 Node2_20_28 2.5000000000000004
R_2_19_28_3 Node2_19_28 GND 706560.0000000001
R_2_19_29_1 Node2_19_29 Node2_19_30 2.5000000000000004
R_2_19_29_2 Node2_19_29 Node2_20_29 2.5000000000000004
R_2_19_29_3 Node2_19_29 GND 706560.0000000001
R_2_19_30_1 Node2_19_30 Node2_19_31 2.5000000000000004
R_2_19_30_2 Node2_19_30 Node2_20_30 2.5000000000000004
R_2_19_30_3 Node2_19_30 GND 706560.0000000001
Rhs_2_19_31_1 Node2_19_31 Node_hs_right 71.54069767441861
R_2_19_31_2 Node2_19_31 Node2_20_31 2.5000000000000004
R_2_19_31_3 Node2_19_31 GND 706560.0000000001
R_2_20_0_1 Node2_20_0 Node2_20_1 2.5000000000000004
Rhs_2_20_0_1 Node2_20_0 Node_hs_right 71.54069767441861
R_2_20_0_2 Node2_20_0 Node2_21_0 2.5000000000000004
R_2_20_0_3 Node2_20_0 GND 706560.0000000001
R_2_20_1_1 Node2_20_1 Node2_20_2 2.5000000000000004
R_2_20_1_2 Node2_20_1 Node2_21_1 2.5000000000000004
R_2_20_1_3 Node2_20_1 GND 706560.0000000001
R_2_20_2_1 Node2_20_2 Node2_20_3 2.5000000000000004
R_2_20_2_2 Node2_20_2 Node2_21_2 2.5000000000000004
R_2_20_2_3 Node2_20_2 GND 706560.0000000001
R_2_20_3_1 Node2_20_3 Node2_20_4 2.5000000000000004
R_2_20_3_2 Node2_20_3 Node2_21_3 2.5000000000000004
R_2_20_3_3 Node2_20_3 GND 706560.0000000001
R_2_20_4_1 Node2_20_4 Node2_20_5 2.5000000000000004
R_2_20_4_2 Node2_20_4 Node2_21_4 2.5000000000000004
R_2_20_4_3 Node2_20_4 GND 706560.0000000001
R_2_20_5_1 Node2_20_5 Node2_20_6 2.5000000000000004
R_2_20_5_2 Node2_20_5 Node2_21_5 2.5000000000000004
R_2_20_5_3 Node2_20_5 GND 706560.0000000001
R_2_20_6_1 Node2_20_6 Node2_20_7 2.5000000000000004
R_2_20_6_2 Node2_20_6 Node2_21_6 2.5000000000000004
R_2_20_6_3 Node2_20_6 GND 706560.0000000001
R_2_20_7_1 Node2_20_7 Node2_20_8 2.5000000000000004
R_2_20_7_2 Node2_20_7 Node2_21_7 2.5000000000000004
R_2_20_7_3 Node2_20_7 GND 706560.0000000001
R_2_20_8_1 Node2_20_8 Node2_20_9 2.5000000000000004
R_2_20_8_2 Node2_20_8 Node2_21_8 2.5000000000000004
R_2_20_8_3 Node2_20_8 GND 706560.0000000001
R_2_20_9_1 Node2_20_9 Node2_20_10 2.5000000000000004
R_2_20_9_2 Node2_20_9 Node2_21_9 2.5000000000000004
R_2_20_9_3 Node2_20_9 GND 706560.0000000001
R_2_20_10_1 Node2_20_10 Node2_20_11 2.5000000000000004
R_2_20_10_2 Node2_20_10 Node2_21_10 2.5000000000000004
R_2_20_10_3 Node2_20_10 GND 706560.0000000001
R_2_20_11_1 Node2_20_11 Node2_20_12 2.5000000000000004
R_2_20_11_2 Node2_20_11 Node2_21_11 2.5000000000000004
R_2_20_11_3 Node2_20_11 GND 706560.0000000001
R_2_20_12_1 Node2_20_12 Node2_20_13 2.5000000000000004
R_2_20_12_2 Node2_20_12 Node2_21_12 2.5000000000000004
R_2_20_12_3 Node2_20_12 GND 706560.0000000001
R_2_20_13_1 Node2_20_13 Node2_20_14 2.5000000000000004
R_2_20_13_2 Node2_20_13 Node2_21_13 2.5000000000000004
R_2_20_13_3 Node2_20_13 GND 706560.0000000001
R_2_20_14_1 Node2_20_14 Node2_20_15 2.5000000000000004
R_2_20_14_2 Node2_20_14 Node2_21_14 2.5000000000000004
R_2_20_14_3 Node2_20_14 GND 706560.0000000001
R_2_20_15_1 Node2_20_15 Node2_20_16 2.5000000000000004
R_2_20_15_2 Node2_20_15 Node2_21_15 2.5000000000000004
R_2_20_15_3 Node2_20_15 GND 706560.0000000001
R_2_20_16_1 Node2_20_16 Node2_20_17 2.5000000000000004
R_2_20_16_2 Node2_20_16 Node2_21_16 2.5000000000000004
R_2_20_16_3 Node2_20_16 GND 706560.0000000001
R_2_20_17_1 Node2_20_17 Node2_20_18 2.5000000000000004
R_2_20_17_2 Node2_20_17 Node2_21_17 2.5000000000000004
R_2_20_17_3 Node2_20_17 GND 706560.0000000001
R_2_20_18_1 Node2_20_18 Node2_20_19 2.5000000000000004
R_2_20_18_2 Node2_20_18 Node2_21_18 2.5000000000000004
R_2_20_18_3 Node2_20_18 GND 706560.0000000001
R_2_20_19_1 Node2_20_19 Node2_20_20 2.5000000000000004
R_2_20_19_2 Node2_20_19 Node2_21_19 2.5000000000000004
R_2_20_19_3 Node2_20_19 GND 706560.0000000001
R_2_20_20_1 Node2_20_20 Node2_20_21 2.5000000000000004
R_2_20_20_2 Node2_20_20 Node2_21_20 2.5000000000000004
R_2_20_20_3 Node2_20_20 GND 706560.0000000001
R_2_20_21_1 Node2_20_21 Node2_20_22 2.5000000000000004
R_2_20_21_2 Node2_20_21 Node2_21_21 2.5000000000000004
R_2_20_21_3 Node2_20_21 GND 706560.0000000001
R_2_20_22_1 Node2_20_22 Node2_20_23 2.5000000000000004
R_2_20_22_2 Node2_20_22 Node2_21_22 2.5000000000000004
R_2_20_22_3 Node2_20_22 GND 706560.0000000001
R_2_20_23_1 Node2_20_23 Node2_20_24 2.5000000000000004
R_2_20_23_2 Node2_20_23 Node2_21_23 2.5000000000000004
R_2_20_23_3 Node2_20_23 GND 706560.0000000001
R_2_20_24_1 Node2_20_24 Node2_20_25 2.5000000000000004
R_2_20_24_2 Node2_20_24 Node2_21_24 2.5000000000000004
R_2_20_24_3 Node2_20_24 GND 706560.0000000001
R_2_20_25_1 Node2_20_25 Node2_20_26 2.5000000000000004
R_2_20_25_2 Node2_20_25 Node2_21_25 2.5000000000000004
R_2_20_25_3 Node2_20_25 GND 706560.0000000001
R_2_20_26_1 Node2_20_26 Node2_20_27 2.5000000000000004
R_2_20_26_2 Node2_20_26 Node2_21_26 2.5000000000000004
R_2_20_26_3 Node2_20_26 GND 706560.0000000001
R_2_20_27_1 Node2_20_27 Node2_20_28 2.5000000000000004
R_2_20_27_2 Node2_20_27 Node2_21_27 2.5000000000000004
R_2_20_27_3 Node2_20_27 GND 706560.0000000001
R_2_20_28_1 Node2_20_28 Node2_20_29 2.5000000000000004
R_2_20_28_2 Node2_20_28 Node2_21_28 2.5000000000000004
R_2_20_28_3 Node2_20_28 GND 706560.0000000001
R_2_20_29_1 Node2_20_29 Node2_20_30 2.5000000000000004
R_2_20_29_2 Node2_20_29 Node2_21_29 2.5000000000000004
R_2_20_29_3 Node2_20_29 GND 706560.0000000001
R_2_20_30_1 Node2_20_30 Node2_20_31 2.5000000000000004
R_2_20_30_2 Node2_20_30 Node2_21_30 2.5000000000000004
R_2_20_30_3 Node2_20_30 GND 706560.0000000001
Rhs_2_20_31_1 Node2_20_31 Node_hs_right 71.54069767441861
R_2_20_31_2 Node2_20_31 Node2_21_31 2.5000000000000004
R_2_20_31_3 Node2_20_31 GND 706560.0000000001
R_2_21_0_1 Node2_21_0 Node2_21_1 2.5000000000000004
Rhs_2_21_0_1 Node2_21_0 Node_hs_right 71.54069767441861
R_2_21_0_2 Node2_21_0 Node2_22_0 2.5000000000000004
R_2_21_0_3 Node2_21_0 GND 706560.0000000001
R_2_21_1_1 Node2_21_1 Node2_21_2 2.5000000000000004
R_2_21_1_2 Node2_21_1 Node2_22_1 2.5000000000000004
R_2_21_1_3 Node2_21_1 GND 706560.0000000001
R_2_21_2_1 Node2_21_2 Node2_21_3 2.5000000000000004
R_2_21_2_2 Node2_21_2 Node2_22_2 2.5000000000000004
R_2_21_2_3 Node2_21_2 GND 706560.0000000001
R_2_21_3_1 Node2_21_3 Node2_21_4 2.5000000000000004
R_2_21_3_2 Node2_21_3 Node2_22_3 2.5000000000000004
R_2_21_3_3 Node2_21_3 GND 706560.0000000001
R_2_21_4_1 Node2_21_4 Node2_21_5 2.5000000000000004
R_2_21_4_2 Node2_21_4 Node2_22_4 2.5000000000000004
R_2_21_4_3 Node2_21_4 GND 706560.0000000001
R_2_21_5_1 Node2_21_5 Node2_21_6 2.5000000000000004
R_2_21_5_2 Node2_21_5 Node2_22_5 2.5000000000000004
R_2_21_5_3 Node2_21_5 GND 706560.0000000001
R_2_21_6_1 Node2_21_6 Node2_21_7 2.5000000000000004
R_2_21_6_2 Node2_21_6 Node2_22_6 2.5000000000000004
R_2_21_6_3 Node2_21_6 GND 706560.0000000001
R_2_21_7_1 Node2_21_7 Node2_21_8 2.5000000000000004
R_2_21_7_2 Node2_21_7 Node2_22_7 2.5000000000000004
R_2_21_7_3 Node2_21_7 GND 706560.0000000001
R_2_21_8_1 Node2_21_8 Node2_21_9 2.5000000000000004
R_2_21_8_2 Node2_21_8 Node2_22_8 2.5000000000000004
R_2_21_8_3 Node2_21_8 GND 706560.0000000001
R_2_21_9_1 Node2_21_9 Node2_21_10 2.5000000000000004
R_2_21_9_2 Node2_21_9 Node2_22_9 2.5000000000000004
R_2_21_9_3 Node2_21_9 GND 706560.0000000001
R_2_21_10_1 Node2_21_10 Node2_21_11 2.5000000000000004
R_2_21_10_2 Node2_21_10 Node2_22_10 2.5000000000000004
R_2_21_10_3 Node2_21_10 GND 706560.0000000001
R_2_21_11_1 Node2_21_11 Node2_21_12 2.5000000000000004
R_2_21_11_2 Node2_21_11 Node2_22_11 2.5000000000000004
R_2_21_11_3 Node2_21_11 GND 706560.0000000001
R_2_21_12_1 Node2_21_12 Node2_21_13 2.5000000000000004
R_2_21_12_2 Node2_21_12 Node2_22_12 2.5000000000000004
R_2_21_12_3 Node2_21_12 GND 706560.0000000001
R_2_21_13_1 Node2_21_13 Node2_21_14 2.5000000000000004
R_2_21_13_2 Node2_21_13 Node2_22_13 2.5000000000000004
R_2_21_13_3 Node2_21_13 GND 706560.0000000001
R_2_21_14_1 Node2_21_14 Node2_21_15 2.5000000000000004
R_2_21_14_2 Node2_21_14 Node2_22_14 2.5000000000000004
R_2_21_14_3 Node2_21_14 GND 706560.0000000001
R_2_21_15_1 Node2_21_15 Node2_21_16 2.5000000000000004
R_2_21_15_2 Node2_21_15 Node2_22_15 2.5000000000000004
R_2_21_15_3 Node2_21_15 GND 706560.0000000001
R_2_21_16_1 Node2_21_16 Node2_21_17 2.5000000000000004
R_2_21_16_2 Node2_21_16 Node2_22_16 2.5000000000000004
R_2_21_16_3 Node2_21_16 GND 706560.0000000001
R_2_21_17_1 Node2_21_17 Node2_21_18 2.5000000000000004
R_2_21_17_2 Node2_21_17 Node2_22_17 2.5000000000000004
R_2_21_17_3 Node2_21_17 GND 706560.0000000001
R_2_21_18_1 Node2_21_18 Node2_21_19 2.5000000000000004
R_2_21_18_2 Node2_21_18 Node2_22_18 2.5000000000000004
R_2_21_18_3 Node2_21_18 GND 706560.0000000001
R_2_21_19_1 Node2_21_19 Node2_21_20 2.5000000000000004
R_2_21_19_2 Node2_21_19 Node2_22_19 2.5000000000000004
R_2_21_19_3 Node2_21_19 GND 706560.0000000001
R_2_21_20_1 Node2_21_20 Node2_21_21 2.5000000000000004
R_2_21_20_2 Node2_21_20 Node2_22_20 2.5000000000000004
R_2_21_20_3 Node2_21_20 GND 706560.0000000001
R_2_21_21_1 Node2_21_21 Node2_21_22 2.5000000000000004
R_2_21_21_2 Node2_21_21 Node2_22_21 2.5000000000000004
R_2_21_21_3 Node2_21_21 GND 706560.0000000001
R_2_21_22_1 Node2_21_22 Node2_21_23 2.5000000000000004
R_2_21_22_2 Node2_21_22 Node2_22_22 2.5000000000000004
R_2_21_22_3 Node2_21_22 GND 706560.0000000001
R_2_21_23_1 Node2_21_23 Node2_21_24 2.5000000000000004
R_2_21_23_2 Node2_21_23 Node2_22_23 2.5000000000000004
R_2_21_23_3 Node2_21_23 GND 706560.0000000001
R_2_21_24_1 Node2_21_24 Node2_21_25 2.5000000000000004
R_2_21_24_2 Node2_21_24 Node2_22_24 2.5000000000000004
R_2_21_24_3 Node2_21_24 GND 706560.0000000001
R_2_21_25_1 Node2_21_25 Node2_21_26 2.5000000000000004
R_2_21_25_2 Node2_21_25 Node2_22_25 2.5000000000000004
R_2_21_25_3 Node2_21_25 GND 706560.0000000001
R_2_21_26_1 Node2_21_26 Node2_21_27 2.5000000000000004
R_2_21_26_2 Node2_21_26 Node2_22_26 2.5000000000000004
R_2_21_26_3 Node2_21_26 GND 706560.0000000001
R_2_21_27_1 Node2_21_27 Node2_21_28 2.5000000000000004
R_2_21_27_2 Node2_21_27 Node2_22_27 2.5000000000000004
R_2_21_27_3 Node2_21_27 GND 706560.0000000001
R_2_21_28_1 Node2_21_28 Node2_21_29 2.5000000000000004
R_2_21_28_2 Node2_21_28 Node2_22_28 2.5000000000000004
R_2_21_28_3 Node2_21_28 GND 706560.0000000001
R_2_21_29_1 Node2_21_29 Node2_21_30 2.5000000000000004
R_2_21_29_2 Node2_21_29 Node2_22_29 2.5000000000000004
R_2_21_29_3 Node2_21_29 GND 706560.0000000001
R_2_21_30_1 Node2_21_30 Node2_21_31 2.5000000000000004
R_2_21_30_2 Node2_21_30 Node2_22_30 2.5000000000000004
R_2_21_30_3 Node2_21_30 GND 706560.0000000001
Rhs_2_21_31_1 Node2_21_31 Node_hs_right 71.54069767441861
R_2_21_31_2 Node2_21_31 Node2_22_31 2.5000000000000004
R_2_21_31_3 Node2_21_31 GND 706560.0000000001
R_2_22_0_1 Node2_22_0 Node2_22_1 2.5000000000000004
Rhs_2_22_0_1 Node2_22_0 Node_hs_right 71.54069767441861
R_2_22_0_2 Node2_22_0 Node2_23_0 2.5000000000000004
R_2_22_0_3 Node2_22_0 GND 706560.0000000001
R_2_22_1_1 Node2_22_1 Node2_22_2 2.5000000000000004
R_2_22_1_2 Node2_22_1 Node2_23_1 2.5000000000000004
R_2_22_1_3 Node2_22_1 GND 706560.0000000001
R_2_22_2_1 Node2_22_2 Node2_22_3 2.5000000000000004
R_2_22_2_2 Node2_22_2 Node2_23_2 2.5000000000000004
R_2_22_2_3 Node2_22_2 GND 706560.0000000001
R_2_22_3_1 Node2_22_3 Node2_22_4 2.5000000000000004
R_2_22_3_2 Node2_22_3 Node2_23_3 2.5000000000000004
R_2_22_3_3 Node2_22_3 GND 706560.0000000001
R_2_22_4_1 Node2_22_4 Node2_22_5 2.5000000000000004
R_2_22_4_2 Node2_22_4 Node2_23_4 2.5000000000000004
R_2_22_4_3 Node2_22_4 GND 706560.0000000001
R_2_22_5_1 Node2_22_5 Node2_22_6 2.5000000000000004
R_2_22_5_2 Node2_22_5 Node2_23_5 2.5000000000000004
R_2_22_5_3 Node2_22_5 GND 706560.0000000001
R_2_22_6_1 Node2_22_6 Node2_22_7 2.5000000000000004
R_2_22_6_2 Node2_22_6 Node2_23_6 2.5000000000000004
R_2_22_6_3 Node2_22_6 GND 706560.0000000001
R_2_22_7_1 Node2_22_7 Node2_22_8 2.5000000000000004
R_2_22_7_2 Node2_22_7 Node2_23_7 2.5000000000000004
R_2_22_7_3 Node2_22_7 GND 706560.0000000001
R_2_22_8_1 Node2_22_8 Node2_22_9 2.5000000000000004
R_2_22_8_2 Node2_22_8 Node2_23_8 2.5000000000000004
R_2_22_8_3 Node2_22_8 GND 706560.0000000001
R_2_22_9_1 Node2_22_9 Node2_22_10 2.5000000000000004
R_2_22_9_2 Node2_22_9 Node2_23_9 2.5000000000000004
R_2_22_9_3 Node2_22_9 GND 706560.0000000001
R_2_22_10_1 Node2_22_10 Node2_22_11 2.5000000000000004
R_2_22_10_2 Node2_22_10 Node2_23_10 2.5000000000000004
R_2_22_10_3 Node2_22_10 GND 706560.0000000001
R_2_22_11_1 Node2_22_11 Node2_22_12 2.5000000000000004
R_2_22_11_2 Node2_22_11 Node2_23_11 2.5000000000000004
R_2_22_11_3 Node2_22_11 GND 706560.0000000001
R_2_22_12_1 Node2_22_12 Node2_22_13 2.5000000000000004
R_2_22_12_2 Node2_22_12 Node2_23_12 2.5000000000000004
R_2_22_12_3 Node2_22_12 GND 706560.0000000001
R_2_22_13_1 Node2_22_13 Node2_22_14 2.5000000000000004
R_2_22_13_2 Node2_22_13 Node2_23_13 2.5000000000000004
R_2_22_13_3 Node2_22_13 GND 706560.0000000001
R_2_22_14_1 Node2_22_14 Node2_22_15 2.5000000000000004
R_2_22_14_2 Node2_22_14 Node2_23_14 2.5000000000000004
R_2_22_14_3 Node2_22_14 GND 706560.0000000001
R_2_22_15_1 Node2_22_15 Node2_22_16 2.5000000000000004
R_2_22_15_2 Node2_22_15 Node2_23_15 2.5000000000000004
R_2_22_15_3 Node2_22_15 GND 706560.0000000001
R_2_22_16_1 Node2_22_16 Node2_22_17 2.5000000000000004
R_2_22_16_2 Node2_22_16 Node2_23_16 2.5000000000000004
R_2_22_16_3 Node2_22_16 GND 706560.0000000001
R_2_22_17_1 Node2_22_17 Node2_22_18 2.5000000000000004
R_2_22_17_2 Node2_22_17 Node2_23_17 2.5000000000000004
R_2_22_17_3 Node2_22_17 GND 706560.0000000001
R_2_22_18_1 Node2_22_18 Node2_22_19 2.5000000000000004
R_2_22_18_2 Node2_22_18 Node2_23_18 2.5000000000000004
R_2_22_18_3 Node2_22_18 GND 706560.0000000001
R_2_22_19_1 Node2_22_19 Node2_22_20 2.5000000000000004
R_2_22_19_2 Node2_22_19 Node2_23_19 2.5000000000000004
R_2_22_19_3 Node2_22_19 GND 706560.0000000001
R_2_22_20_1 Node2_22_20 Node2_22_21 2.5000000000000004
R_2_22_20_2 Node2_22_20 Node2_23_20 2.5000000000000004
R_2_22_20_3 Node2_22_20 GND 706560.0000000001
R_2_22_21_1 Node2_22_21 Node2_22_22 2.5000000000000004
R_2_22_21_2 Node2_22_21 Node2_23_21 2.5000000000000004
R_2_22_21_3 Node2_22_21 GND 706560.0000000001
R_2_22_22_1 Node2_22_22 Node2_22_23 2.5000000000000004
R_2_22_22_2 Node2_22_22 Node2_23_22 2.5000000000000004
R_2_22_22_3 Node2_22_22 GND 706560.0000000001
R_2_22_23_1 Node2_22_23 Node2_22_24 2.5000000000000004
R_2_22_23_2 Node2_22_23 Node2_23_23 2.5000000000000004
R_2_22_23_3 Node2_22_23 GND 706560.0000000001
R_2_22_24_1 Node2_22_24 Node2_22_25 2.5000000000000004
R_2_22_24_2 Node2_22_24 Node2_23_24 2.5000000000000004
R_2_22_24_3 Node2_22_24 GND 706560.0000000001
R_2_22_25_1 Node2_22_25 Node2_22_26 2.5000000000000004
R_2_22_25_2 Node2_22_25 Node2_23_25 2.5000000000000004
R_2_22_25_3 Node2_22_25 GND 706560.0000000001
R_2_22_26_1 Node2_22_26 Node2_22_27 2.5000000000000004
R_2_22_26_2 Node2_22_26 Node2_23_26 2.5000000000000004
R_2_22_26_3 Node2_22_26 GND 706560.0000000001
R_2_22_27_1 Node2_22_27 Node2_22_28 2.5000000000000004
R_2_22_27_2 Node2_22_27 Node2_23_27 2.5000000000000004
R_2_22_27_3 Node2_22_27 GND 706560.0000000001
R_2_22_28_1 Node2_22_28 Node2_22_29 2.5000000000000004
R_2_22_28_2 Node2_22_28 Node2_23_28 2.5000000000000004
R_2_22_28_3 Node2_22_28 GND 706560.0000000001
R_2_22_29_1 Node2_22_29 Node2_22_30 2.5000000000000004
R_2_22_29_2 Node2_22_29 Node2_23_29 2.5000000000000004
R_2_22_29_3 Node2_22_29 GND 706560.0000000001
R_2_22_30_1 Node2_22_30 Node2_22_31 2.5000000000000004
R_2_22_30_2 Node2_22_30 Node2_23_30 2.5000000000000004
R_2_22_30_3 Node2_22_30 GND 706560.0000000001
Rhs_2_22_31_1 Node2_22_31 Node_hs_right 71.54069767441861
R_2_22_31_2 Node2_22_31 Node2_23_31 2.5000000000000004
R_2_22_31_3 Node2_22_31 GND 706560.0000000001
R_2_23_0_1 Node2_23_0 Node2_23_1 2.5000000000000004
Rhs_2_23_0_1 Node2_23_0 Node_hs_right 71.54069767441861
R_2_23_0_2 Node2_23_0 Node2_24_0 2.5000000000000004
R_2_23_0_3 Node2_23_0 GND 706560.0000000001
R_2_23_1_1 Node2_23_1 Node2_23_2 2.5000000000000004
R_2_23_1_2 Node2_23_1 Node2_24_1 2.5000000000000004
R_2_23_1_3 Node2_23_1 GND 706560.0000000001
R_2_23_2_1 Node2_23_2 Node2_23_3 2.5000000000000004
R_2_23_2_2 Node2_23_2 Node2_24_2 2.5000000000000004
R_2_23_2_3 Node2_23_2 GND 706560.0000000001
R_2_23_3_1 Node2_23_3 Node2_23_4 2.5000000000000004
R_2_23_3_2 Node2_23_3 Node2_24_3 2.5000000000000004
R_2_23_3_3 Node2_23_3 GND 706560.0000000001
R_2_23_4_1 Node2_23_4 Node2_23_5 2.5000000000000004
R_2_23_4_2 Node2_23_4 Node2_24_4 2.5000000000000004
R_2_23_4_3 Node2_23_4 GND 706560.0000000001
R_2_23_5_1 Node2_23_5 Node2_23_6 2.5000000000000004
R_2_23_5_2 Node2_23_5 Node2_24_5 2.5000000000000004
R_2_23_5_3 Node2_23_5 GND 706560.0000000001
R_2_23_6_1 Node2_23_6 Node2_23_7 2.5000000000000004
R_2_23_6_2 Node2_23_6 Node2_24_6 2.5000000000000004
R_2_23_6_3 Node2_23_6 GND 706560.0000000001
R_2_23_7_1 Node2_23_7 Node2_23_8 2.5000000000000004
R_2_23_7_2 Node2_23_7 Node2_24_7 2.5000000000000004
R_2_23_7_3 Node2_23_7 GND 706560.0000000001
R_2_23_8_1 Node2_23_8 Node2_23_9 2.5000000000000004
R_2_23_8_2 Node2_23_8 Node2_24_8 2.5000000000000004
R_2_23_8_3 Node2_23_8 GND 706560.0000000001
R_2_23_9_1 Node2_23_9 Node2_23_10 2.5000000000000004
R_2_23_9_2 Node2_23_9 Node2_24_9 2.5000000000000004
R_2_23_9_3 Node2_23_9 GND 706560.0000000001
R_2_23_10_1 Node2_23_10 Node2_23_11 2.5000000000000004
R_2_23_10_2 Node2_23_10 Node2_24_10 2.5000000000000004
R_2_23_10_3 Node2_23_10 GND 706560.0000000001
R_2_23_11_1 Node2_23_11 Node2_23_12 2.5000000000000004
R_2_23_11_2 Node2_23_11 Node2_24_11 2.5000000000000004
R_2_23_11_3 Node2_23_11 GND 706560.0000000001
R_2_23_12_1 Node2_23_12 Node2_23_13 2.5000000000000004
R_2_23_12_2 Node2_23_12 Node2_24_12 2.5000000000000004
R_2_23_12_3 Node2_23_12 GND 706560.0000000001
R_2_23_13_1 Node2_23_13 Node2_23_14 2.5000000000000004
R_2_23_13_2 Node2_23_13 Node2_24_13 2.5000000000000004
R_2_23_13_3 Node2_23_13 GND 706560.0000000001
R_2_23_14_1 Node2_23_14 Node2_23_15 2.5000000000000004
R_2_23_14_2 Node2_23_14 Node2_24_14 2.5000000000000004
R_2_23_14_3 Node2_23_14 GND 706560.0000000001
R_2_23_15_1 Node2_23_15 Node2_23_16 2.5000000000000004
R_2_23_15_2 Node2_23_15 Node2_24_15 2.5000000000000004
R_2_23_15_3 Node2_23_15 GND 706560.0000000001
R_2_23_16_1 Node2_23_16 Node2_23_17 2.5000000000000004
R_2_23_16_2 Node2_23_16 Node2_24_16 2.5000000000000004
R_2_23_16_3 Node2_23_16 GND 706560.0000000001
R_2_23_17_1 Node2_23_17 Node2_23_18 2.5000000000000004
R_2_23_17_2 Node2_23_17 Node2_24_17 2.5000000000000004
R_2_23_17_3 Node2_23_17 GND 706560.0000000001
R_2_23_18_1 Node2_23_18 Node2_23_19 2.5000000000000004
R_2_23_18_2 Node2_23_18 Node2_24_18 2.5000000000000004
R_2_23_18_3 Node2_23_18 GND 706560.0000000001
R_2_23_19_1 Node2_23_19 Node2_23_20 2.5000000000000004
R_2_23_19_2 Node2_23_19 Node2_24_19 2.5000000000000004
R_2_23_19_3 Node2_23_19 GND 706560.0000000001
R_2_23_20_1 Node2_23_20 Node2_23_21 2.5000000000000004
R_2_23_20_2 Node2_23_20 Node2_24_20 2.5000000000000004
R_2_23_20_3 Node2_23_20 GND 706560.0000000001
R_2_23_21_1 Node2_23_21 Node2_23_22 2.5000000000000004
R_2_23_21_2 Node2_23_21 Node2_24_21 2.5000000000000004
R_2_23_21_3 Node2_23_21 GND 706560.0000000001
R_2_23_22_1 Node2_23_22 Node2_23_23 2.5000000000000004
R_2_23_22_2 Node2_23_22 Node2_24_22 2.5000000000000004
R_2_23_22_3 Node2_23_22 GND 706560.0000000001
R_2_23_23_1 Node2_23_23 Node2_23_24 2.5000000000000004
R_2_23_23_2 Node2_23_23 Node2_24_23 2.5000000000000004
R_2_23_23_3 Node2_23_23 GND 706560.0000000001
R_2_23_24_1 Node2_23_24 Node2_23_25 2.5000000000000004
R_2_23_24_2 Node2_23_24 Node2_24_24 2.5000000000000004
R_2_23_24_3 Node2_23_24 GND 706560.0000000001
R_2_23_25_1 Node2_23_25 Node2_23_26 2.5000000000000004
R_2_23_25_2 Node2_23_25 Node2_24_25 2.5000000000000004
R_2_23_25_3 Node2_23_25 GND 706560.0000000001
R_2_23_26_1 Node2_23_26 Node2_23_27 2.5000000000000004
R_2_23_26_2 Node2_23_26 Node2_24_26 2.5000000000000004
R_2_23_26_3 Node2_23_26 GND 706560.0000000001
R_2_23_27_1 Node2_23_27 Node2_23_28 2.5000000000000004
R_2_23_27_2 Node2_23_27 Node2_24_27 2.5000000000000004
R_2_23_27_3 Node2_23_27 GND 706560.0000000001
R_2_23_28_1 Node2_23_28 Node2_23_29 2.5000000000000004
R_2_23_28_2 Node2_23_28 Node2_24_28 2.5000000000000004
R_2_23_28_3 Node2_23_28 GND 706560.0000000001
R_2_23_29_1 Node2_23_29 Node2_23_30 2.5000000000000004
R_2_23_29_2 Node2_23_29 Node2_24_29 2.5000000000000004
R_2_23_29_3 Node2_23_29 GND 706560.0000000001
R_2_23_30_1 Node2_23_30 Node2_23_31 2.5000000000000004
R_2_23_30_2 Node2_23_30 Node2_24_30 2.5000000000000004
R_2_23_30_3 Node2_23_30 GND 706560.0000000001
Rhs_2_23_31_1 Node2_23_31 Node_hs_right 71.54069767441861
R_2_23_31_2 Node2_23_31 Node2_24_31 2.5000000000000004
R_2_23_31_3 Node2_23_31 GND 706560.0000000001
R_2_24_0_1 Node2_24_0 Node2_24_1 2.5000000000000004
Rhs_2_24_0_1 Node2_24_0 Node_hs_right 71.54069767441861
R_2_24_0_2 Node2_24_0 Node2_25_0 2.5000000000000004
R_2_24_0_3 Node2_24_0 GND 706560.0000000001
R_2_24_1_1 Node2_24_1 Node2_24_2 2.5000000000000004
R_2_24_1_2 Node2_24_1 Node2_25_1 2.5000000000000004
R_2_24_1_3 Node2_24_1 GND 706560.0000000001
R_2_24_2_1 Node2_24_2 Node2_24_3 2.5000000000000004
R_2_24_2_2 Node2_24_2 Node2_25_2 2.5000000000000004
R_2_24_2_3 Node2_24_2 GND 706560.0000000001
R_2_24_3_1 Node2_24_3 Node2_24_4 2.5000000000000004
R_2_24_3_2 Node2_24_3 Node2_25_3 2.5000000000000004
R_2_24_3_3 Node2_24_3 GND 706560.0000000001
R_2_24_4_1 Node2_24_4 Node2_24_5 2.5000000000000004
R_2_24_4_2 Node2_24_4 Node2_25_4 2.5000000000000004
R_2_24_4_3 Node2_24_4 GND 706560.0000000001
R_2_24_5_1 Node2_24_5 Node2_24_6 2.5000000000000004
R_2_24_5_2 Node2_24_5 Node2_25_5 2.5000000000000004
R_2_24_5_3 Node2_24_5 GND 706560.0000000001
R_2_24_6_1 Node2_24_6 Node2_24_7 2.5000000000000004
R_2_24_6_2 Node2_24_6 Node2_25_6 2.5000000000000004
R_2_24_6_3 Node2_24_6 GND 706560.0000000001
R_2_24_7_1 Node2_24_7 Node2_24_8 2.5000000000000004
R_2_24_7_2 Node2_24_7 Node2_25_7 2.5000000000000004
R_2_24_7_3 Node2_24_7 GND 706560.0000000001
R_2_24_8_1 Node2_24_8 Node2_24_9 2.5000000000000004
R_2_24_8_2 Node2_24_8 Node2_25_8 2.5000000000000004
R_2_24_8_3 Node2_24_8 GND 706560.0000000001
R_2_24_9_1 Node2_24_9 Node2_24_10 2.5000000000000004
R_2_24_9_2 Node2_24_9 Node2_25_9 2.5000000000000004
R_2_24_9_3 Node2_24_9 GND 706560.0000000001
R_2_24_10_1 Node2_24_10 Node2_24_11 2.5000000000000004
R_2_24_10_2 Node2_24_10 Node2_25_10 2.5000000000000004
R_2_24_10_3 Node2_24_10 GND 706560.0000000001
R_2_24_11_1 Node2_24_11 Node2_24_12 2.5000000000000004
R_2_24_11_2 Node2_24_11 Node2_25_11 2.5000000000000004
R_2_24_11_3 Node2_24_11 GND 706560.0000000001
R_2_24_12_1 Node2_24_12 Node2_24_13 2.5000000000000004
R_2_24_12_2 Node2_24_12 Node2_25_12 2.5000000000000004
R_2_24_12_3 Node2_24_12 GND 706560.0000000001
R_2_24_13_1 Node2_24_13 Node2_24_14 2.5000000000000004
R_2_24_13_2 Node2_24_13 Node2_25_13 2.5000000000000004
R_2_24_13_3 Node2_24_13 GND 706560.0000000001
R_2_24_14_1 Node2_24_14 Node2_24_15 2.5000000000000004
R_2_24_14_2 Node2_24_14 Node2_25_14 2.5000000000000004
R_2_24_14_3 Node2_24_14 GND 706560.0000000001
R_2_24_15_1 Node2_24_15 Node2_24_16 2.5000000000000004
R_2_24_15_2 Node2_24_15 Node2_25_15 2.5000000000000004
R_2_24_15_3 Node2_24_15 GND 706560.0000000001
R_2_24_16_1 Node2_24_16 Node2_24_17 2.5000000000000004
R_2_24_16_2 Node2_24_16 Node2_25_16 2.5000000000000004
R_2_24_16_3 Node2_24_16 GND 706560.0000000001
R_2_24_17_1 Node2_24_17 Node2_24_18 2.5000000000000004
R_2_24_17_2 Node2_24_17 Node2_25_17 2.5000000000000004
R_2_24_17_3 Node2_24_17 GND 706560.0000000001
R_2_24_18_1 Node2_24_18 Node2_24_19 2.5000000000000004
R_2_24_18_2 Node2_24_18 Node2_25_18 2.5000000000000004
R_2_24_18_3 Node2_24_18 GND 706560.0000000001
R_2_24_19_1 Node2_24_19 Node2_24_20 2.5000000000000004
R_2_24_19_2 Node2_24_19 Node2_25_19 2.5000000000000004
R_2_24_19_3 Node2_24_19 GND 706560.0000000001
R_2_24_20_1 Node2_24_20 Node2_24_21 2.5000000000000004
R_2_24_20_2 Node2_24_20 Node2_25_20 2.5000000000000004
R_2_24_20_3 Node2_24_20 GND 706560.0000000001
R_2_24_21_1 Node2_24_21 Node2_24_22 2.5000000000000004
R_2_24_21_2 Node2_24_21 Node2_25_21 2.5000000000000004
R_2_24_21_3 Node2_24_21 GND 706560.0000000001
R_2_24_22_1 Node2_24_22 Node2_24_23 2.5000000000000004
R_2_24_22_2 Node2_24_22 Node2_25_22 2.5000000000000004
R_2_24_22_3 Node2_24_22 GND 706560.0000000001
R_2_24_23_1 Node2_24_23 Node2_24_24 2.5000000000000004
R_2_24_23_2 Node2_24_23 Node2_25_23 2.5000000000000004
R_2_24_23_3 Node2_24_23 GND 706560.0000000001
R_2_24_24_1 Node2_24_24 Node2_24_25 2.5000000000000004
R_2_24_24_2 Node2_24_24 Node2_25_24 2.5000000000000004
R_2_24_24_3 Node2_24_24 GND 706560.0000000001
R_2_24_25_1 Node2_24_25 Node2_24_26 2.5000000000000004
R_2_24_25_2 Node2_24_25 Node2_25_25 2.5000000000000004
R_2_24_25_3 Node2_24_25 GND 706560.0000000001
R_2_24_26_1 Node2_24_26 Node2_24_27 2.5000000000000004
R_2_24_26_2 Node2_24_26 Node2_25_26 2.5000000000000004
R_2_24_26_3 Node2_24_26 GND 706560.0000000001
R_2_24_27_1 Node2_24_27 Node2_24_28 2.5000000000000004
R_2_24_27_2 Node2_24_27 Node2_25_27 2.5000000000000004
R_2_24_27_3 Node2_24_27 GND 706560.0000000001
R_2_24_28_1 Node2_24_28 Node2_24_29 2.5000000000000004
R_2_24_28_2 Node2_24_28 Node2_25_28 2.5000000000000004
R_2_24_28_3 Node2_24_28 GND 706560.0000000001
R_2_24_29_1 Node2_24_29 Node2_24_30 2.5000000000000004
R_2_24_29_2 Node2_24_29 Node2_25_29 2.5000000000000004
R_2_24_29_3 Node2_24_29 GND 706560.0000000001
R_2_24_30_1 Node2_24_30 Node2_24_31 2.5000000000000004
R_2_24_30_2 Node2_24_30 Node2_25_30 2.5000000000000004
R_2_24_30_3 Node2_24_30 GND 706560.0000000001
Rhs_2_24_31_1 Node2_24_31 Node_hs_right 71.54069767441861
R_2_24_31_2 Node2_24_31 Node2_25_31 2.5000000000000004
R_2_24_31_3 Node2_24_31 GND 706560.0000000001
R_2_25_0_1 Node2_25_0 Node2_25_1 2.5000000000000004
Rhs_2_25_0_1 Node2_25_0 Node_hs_right 71.54069767441861
R_2_25_0_2 Node2_25_0 Node2_26_0 2.5000000000000004
R_2_25_0_3 Node2_25_0 GND 706560.0000000001
R_2_25_1_1 Node2_25_1 Node2_25_2 2.5000000000000004
R_2_25_1_2 Node2_25_1 Node2_26_1 2.5000000000000004
R_2_25_1_3 Node2_25_1 GND 706560.0000000001
R_2_25_2_1 Node2_25_2 Node2_25_3 2.5000000000000004
R_2_25_2_2 Node2_25_2 Node2_26_2 2.5000000000000004
R_2_25_2_3 Node2_25_2 GND 706560.0000000001
R_2_25_3_1 Node2_25_3 Node2_25_4 2.5000000000000004
R_2_25_3_2 Node2_25_3 Node2_26_3 2.5000000000000004
R_2_25_3_3 Node2_25_3 GND 706560.0000000001
R_2_25_4_1 Node2_25_4 Node2_25_5 2.5000000000000004
R_2_25_4_2 Node2_25_4 Node2_26_4 2.5000000000000004
R_2_25_4_3 Node2_25_4 GND 706560.0000000001
R_2_25_5_1 Node2_25_5 Node2_25_6 2.5000000000000004
R_2_25_5_2 Node2_25_5 Node2_26_5 2.5000000000000004
R_2_25_5_3 Node2_25_5 GND 706560.0000000001
R_2_25_6_1 Node2_25_6 Node2_25_7 2.5000000000000004
R_2_25_6_2 Node2_25_6 Node2_26_6 2.5000000000000004
R_2_25_6_3 Node2_25_6 GND 706560.0000000001
R_2_25_7_1 Node2_25_7 Node2_25_8 2.5000000000000004
R_2_25_7_2 Node2_25_7 Node2_26_7 2.5000000000000004
R_2_25_7_3 Node2_25_7 GND 706560.0000000001
R_2_25_8_1 Node2_25_8 Node2_25_9 2.5000000000000004
R_2_25_8_2 Node2_25_8 Node2_26_8 2.5000000000000004
R_2_25_8_3 Node2_25_8 GND 706560.0000000001
R_2_25_9_1 Node2_25_9 Node2_25_10 2.5000000000000004
R_2_25_9_2 Node2_25_9 Node2_26_9 2.5000000000000004
R_2_25_9_3 Node2_25_9 GND 706560.0000000001
R_2_25_10_1 Node2_25_10 Node2_25_11 2.5000000000000004
R_2_25_10_2 Node2_25_10 Node2_26_10 2.5000000000000004
R_2_25_10_3 Node2_25_10 GND 706560.0000000001
R_2_25_11_1 Node2_25_11 Node2_25_12 2.5000000000000004
R_2_25_11_2 Node2_25_11 Node2_26_11 2.5000000000000004
R_2_25_11_3 Node2_25_11 GND 706560.0000000001
R_2_25_12_1 Node2_25_12 Node2_25_13 2.5000000000000004
R_2_25_12_2 Node2_25_12 Node2_26_12 2.5000000000000004
R_2_25_12_3 Node2_25_12 GND 706560.0000000001
R_2_25_13_1 Node2_25_13 Node2_25_14 2.5000000000000004
R_2_25_13_2 Node2_25_13 Node2_26_13 2.5000000000000004
R_2_25_13_3 Node2_25_13 GND 706560.0000000001
R_2_25_14_1 Node2_25_14 Node2_25_15 2.5000000000000004
R_2_25_14_2 Node2_25_14 Node2_26_14 2.5000000000000004
R_2_25_14_3 Node2_25_14 GND 706560.0000000001
R_2_25_15_1 Node2_25_15 Node2_25_16 2.5000000000000004
R_2_25_15_2 Node2_25_15 Node2_26_15 2.5000000000000004
R_2_25_15_3 Node2_25_15 GND 706560.0000000001
R_2_25_16_1 Node2_25_16 Node2_25_17 2.5000000000000004
R_2_25_16_2 Node2_25_16 Node2_26_16 2.5000000000000004
R_2_25_16_3 Node2_25_16 GND 706560.0000000001
R_2_25_17_1 Node2_25_17 Node2_25_18 2.5000000000000004
R_2_25_17_2 Node2_25_17 Node2_26_17 2.5000000000000004
R_2_25_17_3 Node2_25_17 GND 706560.0000000001
R_2_25_18_1 Node2_25_18 Node2_25_19 2.5000000000000004
R_2_25_18_2 Node2_25_18 Node2_26_18 2.5000000000000004
R_2_25_18_3 Node2_25_18 GND 706560.0000000001
R_2_25_19_1 Node2_25_19 Node2_25_20 2.5000000000000004
R_2_25_19_2 Node2_25_19 Node2_26_19 2.5000000000000004
R_2_25_19_3 Node2_25_19 GND 706560.0000000001
R_2_25_20_1 Node2_25_20 Node2_25_21 2.5000000000000004
R_2_25_20_2 Node2_25_20 Node2_26_20 2.5000000000000004
R_2_25_20_3 Node2_25_20 GND 706560.0000000001
R_2_25_21_1 Node2_25_21 Node2_25_22 2.5000000000000004
R_2_25_21_2 Node2_25_21 Node2_26_21 2.5000000000000004
R_2_25_21_3 Node2_25_21 GND 706560.0000000001
R_2_25_22_1 Node2_25_22 Node2_25_23 2.5000000000000004
R_2_25_22_2 Node2_25_22 Node2_26_22 2.5000000000000004
R_2_25_22_3 Node2_25_22 GND 706560.0000000001
R_2_25_23_1 Node2_25_23 Node2_25_24 2.5000000000000004
R_2_25_23_2 Node2_25_23 Node2_26_23 2.5000000000000004
R_2_25_23_3 Node2_25_23 GND 706560.0000000001
R_2_25_24_1 Node2_25_24 Node2_25_25 2.5000000000000004
R_2_25_24_2 Node2_25_24 Node2_26_24 2.5000000000000004
R_2_25_24_3 Node2_25_24 GND 706560.0000000001
R_2_25_25_1 Node2_25_25 Node2_25_26 2.5000000000000004
R_2_25_25_2 Node2_25_25 Node2_26_25 2.5000000000000004
R_2_25_25_3 Node2_25_25 GND 706560.0000000001
R_2_25_26_1 Node2_25_26 Node2_25_27 2.5000000000000004
R_2_25_26_2 Node2_25_26 Node2_26_26 2.5000000000000004
R_2_25_26_3 Node2_25_26 GND 706560.0000000001
R_2_25_27_1 Node2_25_27 Node2_25_28 2.5000000000000004
R_2_25_27_2 Node2_25_27 Node2_26_27 2.5000000000000004
R_2_25_27_3 Node2_25_27 GND 706560.0000000001
R_2_25_28_1 Node2_25_28 Node2_25_29 2.5000000000000004
R_2_25_28_2 Node2_25_28 Node2_26_28 2.5000000000000004
R_2_25_28_3 Node2_25_28 GND 706560.0000000001
R_2_25_29_1 Node2_25_29 Node2_25_30 2.5000000000000004
R_2_25_29_2 Node2_25_29 Node2_26_29 2.5000000000000004
R_2_25_29_3 Node2_25_29 GND 706560.0000000001
R_2_25_30_1 Node2_25_30 Node2_25_31 2.5000000000000004
R_2_25_30_2 Node2_25_30 Node2_26_30 2.5000000000000004
R_2_25_30_3 Node2_25_30 GND 706560.0000000001
Rhs_2_25_31_1 Node2_25_31 Node_hs_right 71.54069767441861
R_2_25_31_2 Node2_25_31 Node2_26_31 2.5000000000000004
R_2_25_31_3 Node2_25_31 GND 706560.0000000001
R_2_26_0_1 Node2_26_0 Node2_26_1 2.5000000000000004
Rhs_2_26_0_1 Node2_26_0 Node_hs_right 71.54069767441861
R_2_26_0_2 Node2_26_0 Node2_27_0 2.5000000000000004
R_2_26_0_3 Node2_26_0 GND 706560.0000000001
R_2_26_1_1 Node2_26_1 Node2_26_2 2.5000000000000004
R_2_26_1_2 Node2_26_1 Node2_27_1 2.5000000000000004
R_2_26_1_3 Node2_26_1 GND 706560.0000000001
R_2_26_2_1 Node2_26_2 Node2_26_3 2.5000000000000004
R_2_26_2_2 Node2_26_2 Node2_27_2 2.5000000000000004
R_2_26_2_3 Node2_26_2 GND 706560.0000000001
R_2_26_3_1 Node2_26_3 Node2_26_4 2.5000000000000004
R_2_26_3_2 Node2_26_3 Node2_27_3 2.5000000000000004
R_2_26_3_3 Node2_26_3 GND 706560.0000000001
R_2_26_4_1 Node2_26_4 Node2_26_5 2.5000000000000004
R_2_26_4_2 Node2_26_4 Node2_27_4 2.5000000000000004
R_2_26_4_3 Node2_26_4 GND 706560.0000000001
R_2_26_5_1 Node2_26_5 Node2_26_6 2.5000000000000004
R_2_26_5_2 Node2_26_5 Node2_27_5 2.5000000000000004
R_2_26_5_3 Node2_26_5 GND 706560.0000000001
R_2_26_6_1 Node2_26_6 Node2_26_7 2.5000000000000004
R_2_26_6_2 Node2_26_6 Node2_27_6 2.5000000000000004
R_2_26_6_3 Node2_26_6 GND 706560.0000000001
R_2_26_7_1 Node2_26_7 Node2_26_8 2.5000000000000004
R_2_26_7_2 Node2_26_7 Node2_27_7 2.5000000000000004
R_2_26_7_3 Node2_26_7 GND 706560.0000000001
R_2_26_8_1 Node2_26_8 Node2_26_9 2.5000000000000004
R_2_26_8_2 Node2_26_8 Node2_27_8 2.5000000000000004
R_2_26_8_3 Node2_26_8 GND 706560.0000000001
R_2_26_9_1 Node2_26_9 Node2_26_10 2.5000000000000004
R_2_26_9_2 Node2_26_9 Node2_27_9 2.5000000000000004
R_2_26_9_3 Node2_26_9 GND 706560.0000000001
R_2_26_10_1 Node2_26_10 Node2_26_11 2.5000000000000004
R_2_26_10_2 Node2_26_10 Node2_27_10 2.5000000000000004
R_2_26_10_3 Node2_26_10 GND 706560.0000000001
R_2_26_11_1 Node2_26_11 Node2_26_12 2.5000000000000004
R_2_26_11_2 Node2_26_11 Node2_27_11 2.5000000000000004
R_2_26_11_3 Node2_26_11 GND 706560.0000000001
R_2_26_12_1 Node2_26_12 Node2_26_13 2.5000000000000004
R_2_26_12_2 Node2_26_12 Node2_27_12 2.5000000000000004
R_2_26_12_3 Node2_26_12 GND 706560.0000000001
R_2_26_13_1 Node2_26_13 Node2_26_14 2.5000000000000004
R_2_26_13_2 Node2_26_13 Node2_27_13 2.5000000000000004
R_2_26_13_3 Node2_26_13 GND 706560.0000000001
R_2_26_14_1 Node2_26_14 Node2_26_15 2.5000000000000004
R_2_26_14_2 Node2_26_14 Node2_27_14 2.5000000000000004
R_2_26_14_3 Node2_26_14 GND 706560.0000000001
R_2_26_15_1 Node2_26_15 Node2_26_16 2.5000000000000004
R_2_26_15_2 Node2_26_15 Node2_27_15 2.5000000000000004
R_2_26_15_3 Node2_26_15 GND 706560.0000000001
R_2_26_16_1 Node2_26_16 Node2_26_17 2.5000000000000004
R_2_26_16_2 Node2_26_16 Node2_27_16 2.5000000000000004
R_2_26_16_3 Node2_26_16 GND 706560.0000000001
R_2_26_17_1 Node2_26_17 Node2_26_18 2.5000000000000004
R_2_26_17_2 Node2_26_17 Node2_27_17 2.5000000000000004
R_2_26_17_3 Node2_26_17 GND 706560.0000000001
R_2_26_18_1 Node2_26_18 Node2_26_19 2.5000000000000004
R_2_26_18_2 Node2_26_18 Node2_27_18 2.5000000000000004
R_2_26_18_3 Node2_26_18 GND 706560.0000000001
R_2_26_19_1 Node2_26_19 Node2_26_20 2.5000000000000004
R_2_26_19_2 Node2_26_19 Node2_27_19 2.5000000000000004
R_2_26_19_3 Node2_26_19 GND 706560.0000000001
R_2_26_20_1 Node2_26_20 Node2_26_21 2.5000000000000004
R_2_26_20_2 Node2_26_20 Node2_27_20 2.5000000000000004
R_2_26_20_3 Node2_26_20 GND 706560.0000000001
R_2_26_21_1 Node2_26_21 Node2_26_22 2.5000000000000004
R_2_26_21_2 Node2_26_21 Node2_27_21 2.5000000000000004
R_2_26_21_3 Node2_26_21 GND 706560.0000000001
R_2_26_22_1 Node2_26_22 Node2_26_23 2.5000000000000004
R_2_26_22_2 Node2_26_22 Node2_27_22 2.5000000000000004
R_2_26_22_3 Node2_26_22 GND 706560.0000000001
R_2_26_23_1 Node2_26_23 Node2_26_24 2.5000000000000004
R_2_26_23_2 Node2_26_23 Node2_27_23 2.5000000000000004
R_2_26_23_3 Node2_26_23 GND 706560.0000000001
R_2_26_24_1 Node2_26_24 Node2_26_25 2.5000000000000004
R_2_26_24_2 Node2_26_24 Node2_27_24 2.5000000000000004
R_2_26_24_3 Node2_26_24 GND 706560.0000000001
R_2_26_25_1 Node2_26_25 Node2_26_26 2.5000000000000004
R_2_26_25_2 Node2_26_25 Node2_27_25 2.5000000000000004
R_2_26_25_3 Node2_26_25 GND 706560.0000000001
R_2_26_26_1 Node2_26_26 Node2_26_27 2.5000000000000004
R_2_26_26_2 Node2_26_26 Node2_27_26 2.5000000000000004
R_2_26_26_3 Node2_26_26 GND 706560.0000000001
R_2_26_27_1 Node2_26_27 Node2_26_28 2.5000000000000004
R_2_26_27_2 Node2_26_27 Node2_27_27 2.5000000000000004
R_2_26_27_3 Node2_26_27 GND 706560.0000000001
R_2_26_28_1 Node2_26_28 Node2_26_29 2.5000000000000004
R_2_26_28_2 Node2_26_28 Node2_27_28 2.5000000000000004
R_2_26_28_3 Node2_26_28 GND 706560.0000000001
R_2_26_29_1 Node2_26_29 Node2_26_30 2.5000000000000004
R_2_26_29_2 Node2_26_29 Node2_27_29 2.5000000000000004
R_2_26_29_3 Node2_26_29 GND 706560.0000000001
R_2_26_30_1 Node2_26_30 Node2_26_31 2.5000000000000004
R_2_26_30_2 Node2_26_30 Node2_27_30 2.5000000000000004
R_2_26_30_3 Node2_26_30 GND 706560.0000000001
Rhs_2_26_31_1 Node2_26_31 Node_hs_right 71.54069767441861
R_2_26_31_2 Node2_26_31 Node2_27_31 2.5000000000000004
R_2_26_31_3 Node2_26_31 GND 706560.0000000001
R_2_27_0_1 Node2_27_0 Node2_27_1 2.5000000000000004
Rhs_2_27_0_1 Node2_27_0 Node_hs_right 71.54069767441861
R_2_27_0_2 Node2_27_0 Node2_28_0 2.5000000000000004
R_2_27_0_3 Node2_27_0 GND 706560.0000000001
R_2_27_1_1 Node2_27_1 Node2_27_2 2.5000000000000004
R_2_27_1_2 Node2_27_1 Node2_28_1 2.5000000000000004
R_2_27_1_3 Node2_27_1 GND 706560.0000000001
R_2_27_2_1 Node2_27_2 Node2_27_3 2.5000000000000004
R_2_27_2_2 Node2_27_2 Node2_28_2 2.5000000000000004
R_2_27_2_3 Node2_27_2 GND 706560.0000000001
R_2_27_3_1 Node2_27_3 Node2_27_4 2.5000000000000004
R_2_27_3_2 Node2_27_3 Node2_28_3 2.5000000000000004
R_2_27_3_3 Node2_27_3 GND 706560.0000000001
R_2_27_4_1 Node2_27_4 Node2_27_5 2.5000000000000004
R_2_27_4_2 Node2_27_4 Node2_28_4 2.5000000000000004
R_2_27_4_3 Node2_27_4 GND 706560.0000000001
R_2_27_5_1 Node2_27_5 Node2_27_6 2.5000000000000004
R_2_27_5_2 Node2_27_5 Node2_28_5 2.5000000000000004
R_2_27_5_3 Node2_27_5 GND 706560.0000000001
R_2_27_6_1 Node2_27_6 Node2_27_7 2.5000000000000004
R_2_27_6_2 Node2_27_6 Node2_28_6 2.5000000000000004
R_2_27_6_3 Node2_27_6 GND 706560.0000000001
R_2_27_7_1 Node2_27_7 Node2_27_8 2.5000000000000004
R_2_27_7_2 Node2_27_7 Node2_28_7 2.5000000000000004
R_2_27_7_3 Node2_27_7 GND 706560.0000000001
R_2_27_8_1 Node2_27_8 Node2_27_9 2.5000000000000004
R_2_27_8_2 Node2_27_8 Node2_28_8 2.5000000000000004
R_2_27_8_3 Node2_27_8 GND 706560.0000000001
R_2_27_9_1 Node2_27_9 Node2_27_10 2.5000000000000004
R_2_27_9_2 Node2_27_9 Node2_28_9 2.5000000000000004
R_2_27_9_3 Node2_27_9 GND 706560.0000000001
R_2_27_10_1 Node2_27_10 Node2_27_11 2.5000000000000004
R_2_27_10_2 Node2_27_10 Node2_28_10 2.5000000000000004
R_2_27_10_3 Node2_27_10 GND 706560.0000000001
R_2_27_11_1 Node2_27_11 Node2_27_12 2.5000000000000004
R_2_27_11_2 Node2_27_11 Node2_28_11 2.5000000000000004
R_2_27_11_3 Node2_27_11 GND 706560.0000000001
R_2_27_12_1 Node2_27_12 Node2_27_13 2.5000000000000004
R_2_27_12_2 Node2_27_12 Node2_28_12 2.5000000000000004
R_2_27_12_3 Node2_27_12 GND 706560.0000000001
R_2_27_13_1 Node2_27_13 Node2_27_14 2.5000000000000004
R_2_27_13_2 Node2_27_13 Node2_28_13 2.5000000000000004
R_2_27_13_3 Node2_27_13 GND 706560.0000000001
R_2_27_14_1 Node2_27_14 Node2_27_15 2.5000000000000004
R_2_27_14_2 Node2_27_14 Node2_28_14 2.5000000000000004
R_2_27_14_3 Node2_27_14 GND 706560.0000000001
R_2_27_15_1 Node2_27_15 Node2_27_16 2.5000000000000004
R_2_27_15_2 Node2_27_15 Node2_28_15 2.5000000000000004
R_2_27_15_3 Node2_27_15 GND 706560.0000000001
R_2_27_16_1 Node2_27_16 Node2_27_17 2.5000000000000004
R_2_27_16_2 Node2_27_16 Node2_28_16 2.5000000000000004
R_2_27_16_3 Node2_27_16 GND 706560.0000000001
R_2_27_17_1 Node2_27_17 Node2_27_18 2.5000000000000004
R_2_27_17_2 Node2_27_17 Node2_28_17 2.5000000000000004
R_2_27_17_3 Node2_27_17 GND 706560.0000000001
R_2_27_18_1 Node2_27_18 Node2_27_19 2.5000000000000004
R_2_27_18_2 Node2_27_18 Node2_28_18 2.5000000000000004
R_2_27_18_3 Node2_27_18 GND 706560.0000000001
R_2_27_19_1 Node2_27_19 Node2_27_20 2.5000000000000004
R_2_27_19_2 Node2_27_19 Node2_28_19 2.5000000000000004
R_2_27_19_3 Node2_27_19 GND 706560.0000000001
R_2_27_20_1 Node2_27_20 Node2_27_21 2.5000000000000004
R_2_27_20_2 Node2_27_20 Node2_28_20 2.5000000000000004
R_2_27_20_3 Node2_27_20 GND 706560.0000000001
R_2_27_21_1 Node2_27_21 Node2_27_22 2.5000000000000004
R_2_27_21_2 Node2_27_21 Node2_28_21 2.5000000000000004
R_2_27_21_3 Node2_27_21 GND 706560.0000000001
R_2_27_22_1 Node2_27_22 Node2_27_23 2.5000000000000004
R_2_27_22_2 Node2_27_22 Node2_28_22 2.5000000000000004
R_2_27_22_3 Node2_27_22 GND 706560.0000000001
R_2_27_23_1 Node2_27_23 Node2_27_24 2.5000000000000004
R_2_27_23_2 Node2_27_23 Node2_28_23 2.5000000000000004
R_2_27_23_3 Node2_27_23 GND 706560.0000000001
R_2_27_24_1 Node2_27_24 Node2_27_25 2.5000000000000004
R_2_27_24_2 Node2_27_24 Node2_28_24 2.5000000000000004
R_2_27_24_3 Node2_27_24 GND 706560.0000000001
R_2_27_25_1 Node2_27_25 Node2_27_26 2.5000000000000004
R_2_27_25_2 Node2_27_25 Node2_28_25 2.5000000000000004
R_2_27_25_3 Node2_27_25 GND 706560.0000000001
R_2_27_26_1 Node2_27_26 Node2_27_27 2.5000000000000004
R_2_27_26_2 Node2_27_26 Node2_28_26 2.5000000000000004
R_2_27_26_3 Node2_27_26 GND 706560.0000000001
R_2_27_27_1 Node2_27_27 Node2_27_28 2.5000000000000004
R_2_27_27_2 Node2_27_27 Node2_28_27 2.5000000000000004
R_2_27_27_3 Node2_27_27 GND 706560.0000000001
R_2_27_28_1 Node2_27_28 Node2_27_29 2.5000000000000004
R_2_27_28_2 Node2_27_28 Node2_28_28 2.5000000000000004
R_2_27_28_3 Node2_27_28 GND 706560.0000000001
R_2_27_29_1 Node2_27_29 Node2_27_30 2.5000000000000004
R_2_27_29_2 Node2_27_29 Node2_28_29 2.5000000000000004
R_2_27_29_3 Node2_27_29 GND 706560.0000000001
R_2_27_30_1 Node2_27_30 Node2_27_31 2.5000000000000004
R_2_27_30_2 Node2_27_30 Node2_28_30 2.5000000000000004
R_2_27_30_3 Node2_27_30 GND 706560.0000000001
Rhs_2_27_31_1 Node2_27_31 Node_hs_right 71.54069767441861
R_2_27_31_2 Node2_27_31 Node2_28_31 2.5000000000000004
R_2_27_31_3 Node2_27_31 GND 706560.0000000001
R_2_28_0_1 Node2_28_0 Node2_28_1 2.5000000000000004
Rhs_2_28_0_1 Node2_28_0 Node_hs_right 71.54069767441861
R_2_28_0_2 Node2_28_0 Node2_29_0 2.5000000000000004
R_2_28_0_3 Node2_28_0 GND 706560.0000000001
R_2_28_1_1 Node2_28_1 Node2_28_2 2.5000000000000004
R_2_28_1_2 Node2_28_1 Node2_29_1 2.5000000000000004
R_2_28_1_3 Node2_28_1 GND 706560.0000000001
R_2_28_2_1 Node2_28_2 Node2_28_3 2.5000000000000004
R_2_28_2_2 Node2_28_2 Node2_29_2 2.5000000000000004
R_2_28_2_3 Node2_28_2 GND 706560.0000000001
R_2_28_3_1 Node2_28_3 Node2_28_4 2.5000000000000004
R_2_28_3_2 Node2_28_3 Node2_29_3 2.5000000000000004
R_2_28_3_3 Node2_28_3 GND 706560.0000000001
R_2_28_4_1 Node2_28_4 Node2_28_5 2.5000000000000004
R_2_28_4_2 Node2_28_4 Node2_29_4 2.5000000000000004
R_2_28_4_3 Node2_28_4 GND 706560.0000000001
R_2_28_5_1 Node2_28_5 Node2_28_6 2.5000000000000004
R_2_28_5_2 Node2_28_5 Node2_29_5 2.5000000000000004
R_2_28_5_3 Node2_28_5 GND 706560.0000000001
R_2_28_6_1 Node2_28_6 Node2_28_7 2.5000000000000004
R_2_28_6_2 Node2_28_6 Node2_29_6 2.5000000000000004
R_2_28_6_3 Node2_28_6 GND 706560.0000000001
R_2_28_7_1 Node2_28_7 Node2_28_8 2.5000000000000004
R_2_28_7_2 Node2_28_7 Node2_29_7 2.5000000000000004
R_2_28_7_3 Node2_28_7 GND 706560.0000000001
R_2_28_8_1 Node2_28_8 Node2_28_9 2.5000000000000004
R_2_28_8_2 Node2_28_8 Node2_29_8 2.5000000000000004
R_2_28_8_3 Node2_28_8 GND 706560.0000000001
R_2_28_9_1 Node2_28_9 Node2_28_10 2.5000000000000004
R_2_28_9_2 Node2_28_9 Node2_29_9 2.5000000000000004
R_2_28_9_3 Node2_28_9 GND 706560.0000000001
R_2_28_10_1 Node2_28_10 Node2_28_11 2.5000000000000004
R_2_28_10_2 Node2_28_10 Node2_29_10 2.5000000000000004
R_2_28_10_3 Node2_28_10 GND 706560.0000000001
R_2_28_11_1 Node2_28_11 Node2_28_12 2.5000000000000004
R_2_28_11_2 Node2_28_11 Node2_29_11 2.5000000000000004
R_2_28_11_3 Node2_28_11 GND 706560.0000000001
R_2_28_12_1 Node2_28_12 Node2_28_13 2.5000000000000004
R_2_28_12_2 Node2_28_12 Node2_29_12 2.5000000000000004
R_2_28_12_3 Node2_28_12 GND 706560.0000000001
R_2_28_13_1 Node2_28_13 Node2_28_14 2.5000000000000004
R_2_28_13_2 Node2_28_13 Node2_29_13 2.5000000000000004
R_2_28_13_3 Node2_28_13 GND 706560.0000000001
R_2_28_14_1 Node2_28_14 Node2_28_15 2.5000000000000004
R_2_28_14_2 Node2_28_14 Node2_29_14 2.5000000000000004
R_2_28_14_3 Node2_28_14 GND 706560.0000000001
R_2_28_15_1 Node2_28_15 Node2_28_16 2.5000000000000004
R_2_28_15_2 Node2_28_15 Node2_29_15 2.5000000000000004
R_2_28_15_3 Node2_28_15 GND 706560.0000000001
R_2_28_16_1 Node2_28_16 Node2_28_17 2.5000000000000004
R_2_28_16_2 Node2_28_16 Node2_29_16 2.5000000000000004
R_2_28_16_3 Node2_28_16 GND 706560.0000000001
R_2_28_17_1 Node2_28_17 Node2_28_18 2.5000000000000004
R_2_28_17_2 Node2_28_17 Node2_29_17 2.5000000000000004
R_2_28_17_3 Node2_28_17 GND 706560.0000000001
R_2_28_18_1 Node2_28_18 Node2_28_19 2.5000000000000004
R_2_28_18_2 Node2_28_18 Node2_29_18 2.5000000000000004
R_2_28_18_3 Node2_28_18 GND 706560.0000000001
R_2_28_19_1 Node2_28_19 Node2_28_20 2.5000000000000004
R_2_28_19_2 Node2_28_19 Node2_29_19 2.5000000000000004
R_2_28_19_3 Node2_28_19 GND 706560.0000000001
R_2_28_20_1 Node2_28_20 Node2_28_21 2.5000000000000004
R_2_28_20_2 Node2_28_20 Node2_29_20 2.5000000000000004
R_2_28_20_3 Node2_28_20 GND 706560.0000000001
R_2_28_21_1 Node2_28_21 Node2_28_22 2.5000000000000004
R_2_28_21_2 Node2_28_21 Node2_29_21 2.5000000000000004
R_2_28_21_3 Node2_28_21 GND 706560.0000000001
R_2_28_22_1 Node2_28_22 Node2_28_23 2.5000000000000004
R_2_28_22_2 Node2_28_22 Node2_29_22 2.5000000000000004
R_2_28_22_3 Node2_28_22 GND 706560.0000000001
R_2_28_23_1 Node2_28_23 Node2_28_24 2.5000000000000004
R_2_28_23_2 Node2_28_23 Node2_29_23 2.5000000000000004
R_2_28_23_3 Node2_28_23 GND 706560.0000000001
R_2_28_24_1 Node2_28_24 Node2_28_25 2.5000000000000004
R_2_28_24_2 Node2_28_24 Node2_29_24 2.5000000000000004
R_2_28_24_3 Node2_28_24 GND 706560.0000000001
R_2_28_25_1 Node2_28_25 Node2_28_26 2.5000000000000004
R_2_28_25_2 Node2_28_25 Node2_29_25 2.5000000000000004
R_2_28_25_3 Node2_28_25 GND 706560.0000000001
R_2_28_26_1 Node2_28_26 Node2_28_27 2.5000000000000004
R_2_28_26_2 Node2_28_26 Node2_29_26 2.5000000000000004
R_2_28_26_3 Node2_28_26 GND 706560.0000000001
R_2_28_27_1 Node2_28_27 Node2_28_28 2.5000000000000004
R_2_28_27_2 Node2_28_27 Node2_29_27 2.5000000000000004
R_2_28_27_3 Node2_28_27 GND 706560.0000000001
R_2_28_28_1 Node2_28_28 Node2_28_29 2.5000000000000004
R_2_28_28_2 Node2_28_28 Node2_29_28 2.5000000000000004
R_2_28_28_3 Node2_28_28 GND 706560.0000000001
R_2_28_29_1 Node2_28_29 Node2_28_30 2.5000000000000004
R_2_28_29_2 Node2_28_29 Node2_29_29 2.5000000000000004
R_2_28_29_3 Node2_28_29 GND 706560.0000000001
R_2_28_30_1 Node2_28_30 Node2_28_31 2.5000000000000004
R_2_28_30_2 Node2_28_30 Node2_29_30 2.5000000000000004
R_2_28_30_3 Node2_28_30 GND 706560.0000000001
Rhs_2_28_31_1 Node2_28_31 Node_hs_right 71.54069767441861
R_2_28_31_2 Node2_28_31 Node2_29_31 2.5000000000000004
R_2_28_31_3 Node2_28_31 GND 706560.0000000001
R_2_29_0_1 Node2_29_0 Node2_29_1 2.5000000000000004
Rhs_2_29_0_1 Node2_29_0 Node_hs_right 71.54069767441861
R_2_29_0_2 Node2_29_0 Node2_30_0 2.5000000000000004
R_2_29_0_3 Node2_29_0 GND 706560.0000000001
R_2_29_1_1 Node2_29_1 Node2_29_2 2.5000000000000004
R_2_29_1_2 Node2_29_1 Node2_30_1 2.5000000000000004
R_2_29_1_3 Node2_29_1 GND 706560.0000000001
R_2_29_2_1 Node2_29_2 Node2_29_3 2.5000000000000004
R_2_29_2_2 Node2_29_2 Node2_30_2 2.5000000000000004
R_2_29_2_3 Node2_29_2 GND 706560.0000000001
R_2_29_3_1 Node2_29_3 Node2_29_4 2.5000000000000004
R_2_29_3_2 Node2_29_3 Node2_30_3 2.5000000000000004
R_2_29_3_3 Node2_29_3 GND 706560.0000000001
R_2_29_4_1 Node2_29_4 Node2_29_5 2.5000000000000004
R_2_29_4_2 Node2_29_4 Node2_30_4 2.5000000000000004
R_2_29_4_3 Node2_29_4 GND 706560.0000000001
R_2_29_5_1 Node2_29_5 Node2_29_6 2.5000000000000004
R_2_29_5_2 Node2_29_5 Node2_30_5 2.5000000000000004
R_2_29_5_3 Node2_29_5 GND 706560.0000000001
R_2_29_6_1 Node2_29_6 Node2_29_7 2.5000000000000004
R_2_29_6_2 Node2_29_6 Node2_30_6 2.5000000000000004
R_2_29_6_3 Node2_29_6 GND 706560.0000000001
R_2_29_7_1 Node2_29_7 Node2_29_8 2.5000000000000004
R_2_29_7_2 Node2_29_7 Node2_30_7 2.5000000000000004
R_2_29_7_3 Node2_29_7 GND 706560.0000000001
R_2_29_8_1 Node2_29_8 Node2_29_9 2.5000000000000004
R_2_29_8_2 Node2_29_8 Node2_30_8 2.5000000000000004
R_2_29_8_3 Node2_29_8 GND 706560.0000000001
R_2_29_9_1 Node2_29_9 Node2_29_10 2.5000000000000004
R_2_29_9_2 Node2_29_9 Node2_30_9 2.5000000000000004
R_2_29_9_3 Node2_29_9 GND 706560.0000000001
R_2_29_10_1 Node2_29_10 Node2_29_11 2.5000000000000004
R_2_29_10_2 Node2_29_10 Node2_30_10 2.5000000000000004
R_2_29_10_3 Node2_29_10 GND 706560.0000000001
R_2_29_11_1 Node2_29_11 Node2_29_12 2.5000000000000004
R_2_29_11_2 Node2_29_11 Node2_30_11 2.5000000000000004
R_2_29_11_3 Node2_29_11 GND 706560.0000000001
R_2_29_12_1 Node2_29_12 Node2_29_13 2.5000000000000004
R_2_29_12_2 Node2_29_12 Node2_30_12 2.5000000000000004
R_2_29_12_3 Node2_29_12 GND 706560.0000000001
R_2_29_13_1 Node2_29_13 Node2_29_14 2.5000000000000004
R_2_29_13_2 Node2_29_13 Node2_30_13 2.5000000000000004
R_2_29_13_3 Node2_29_13 GND 706560.0000000001
R_2_29_14_1 Node2_29_14 Node2_29_15 2.5000000000000004
R_2_29_14_2 Node2_29_14 Node2_30_14 2.5000000000000004
R_2_29_14_3 Node2_29_14 GND 706560.0000000001
R_2_29_15_1 Node2_29_15 Node2_29_16 2.5000000000000004
R_2_29_15_2 Node2_29_15 Node2_30_15 2.5000000000000004
R_2_29_15_3 Node2_29_15 GND 706560.0000000001
R_2_29_16_1 Node2_29_16 Node2_29_17 2.5000000000000004
R_2_29_16_2 Node2_29_16 Node2_30_16 2.5000000000000004
R_2_29_16_3 Node2_29_16 GND 706560.0000000001
R_2_29_17_1 Node2_29_17 Node2_29_18 2.5000000000000004
R_2_29_17_2 Node2_29_17 Node2_30_17 2.5000000000000004
R_2_29_17_3 Node2_29_17 GND 706560.0000000001
R_2_29_18_1 Node2_29_18 Node2_29_19 2.5000000000000004
R_2_29_18_2 Node2_29_18 Node2_30_18 2.5000000000000004
R_2_29_18_3 Node2_29_18 GND 706560.0000000001
R_2_29_19_1 Node2_29_19 Node2_29_20 2.5000000000000004
R_2_29_19_2 Node2_29_19 Node2_30_19 2.5000000000000004
R_2_29_19_3 Node2_29_19 GND 706560.0000000001
R_2_29_20_1 Node2_29_20 Node2_29_21 2.5000000000000004
R_2_29_20_2 Node2_29_20 Node2_30_20 2.5000000000000004
R_2_29_20_3 Node2_29_20 GND 706560.0000000001
R_2_29_21_1 Node2_29_21 Node2_29_22 2.5000000000000004
R_2_29_21_2 Node2_29_21 Node2_30_21 2.5000000000000004
R_2_29_21_3 Node2_29_21 GND 706560.0000000001
R_2_29_22_1 Node2_29_22 Node2_29_23 2.5000000000000004
R_2_29_22_2 Node2_29_22 Node2_30_22 2.5000000000000004
R_2_29_22_3 Node2_29_22 GND 706560.0000000001
R_2_29_23_1 Node2_29_23 Node2_29_24 2.5000000000000004
R_2_29_23_2 Node2_29_23 Node2_30_23 2.5000000000000004
R_2_29_23_3 Node2_29_23 GND 706560.0000000001
R_2_29_24_1 Node2_29_24 Node2_29_25 2.5000000000000004
R_2_29_24_2 Node2_29_24 Node2_30_24 2.5000000000000004
R_2_29_24_3 Node2_29_24 GND 706560.0000000001
R_2_29_25_1 Node2_29_25 Node2_29_26 2.5000000000000004
R_2_29_25_2 Node2_29_25 Node2_30_25 2.5000000000000004
R_2_29_25_3 Node2_29_25 GND 706560.0000000001
R_2_29_26_1 Node2_29_26 Node2_29_27 2.5000000000000004
R_2_29_26_2 Node2_29_26 Node2_30_26 2.5000000000000004
R_2_29_26_3 Node2_29_26 GND 706560.0000000001
R_2_29_27_1 Node2_29_27 Node2_29_28 2.5000000000000004
R_2_29_27_2 Node2_29_27 Node2_30_27 2.5000000000000004
R_2_29_27_3 Node2_29_27 GND 706560.0000000001
R_2_29_28_1 Node2_29_28 Node2_29_29 2.5000000000000004
R_2_29_28_2 Node2_29_28 Node2_30_28 2.5000000000000004
R_2_29_28_3 Node2_29_28 GND 706560.0000000001
R_2_29_29_1 Node2_29_29 Node2_29_30 2.5000000000000004
R_2_29_29_2 Node2_29_29 Node2_30_29 2.5000000000000004
R_2_29_29_3 Node2_29_29 GND 706560.0000000001
R_2_29_30_1 Node2_29_30 Node2_29_31 2.5000000000000004
R_2_29_30_2 Node2_29_30 Node2_30_30 2.5000000000000004
R_2_29_30_3 Node2_29_30 GND 706560.0000000001
Rhs_2_29_31_1 Node2_29_31 Node_hs_right 71.54069767441861
R_2_29_31_2 Node2_29_31 Node2_30_31 2.5000000000000004
R_2_29_31_3 Node2_29_31 GND 706560.0000000001
R_2_30_0_1 Node2_30_0 Node2_30_1 2.5000000000000004
Rhs_2_30_0_1 Node2_30_0 Node_hs_right 71.54069767441861
R_2_30_0_2 Node2_30_0 Node2_31_0 2.5000000000000004
R_2_30_0_3 Node2_30_0 GND 706560.0000000001
R_2_30_1_1 Node2_30_1 Node2_30_2 2.5000000000000004
R_2_30_1_2 Node2_30_1 Node2_31_1 2.5000000000000004
R_2_30_1_3 Node2_30_1 GND 706560.0000000001
R_2_30_2_1 Node2_30_2 Node2_30_3 2.5000000000000004
R_2_30_2_2 Node2_30_2 Node2_31_2 2.5000000000000004
R_2_30_2_3 Node2_30_2 GND 706560.0000000001
R_2_30_3_1 Node2_30_3 Node2_30_4 2.5000000000000004
R_2_30_3_2 Node2_30_3 Node2_31_3 2.5000000000000004
R_2_30_3_3 Node2_30_3 GND 706560.0000000001
R_2_30_4_1 Node2_30_4 Node2_30_5 2.5000000000000004
R_2_30_4_2 Node2_30_4 Node2_31_4 2.5000000000000004
R_2_30_4_3 Node2_30_4 GND 706560.0000000001
R_2_30_5_1 Node2_30_5 Node2_30_6 2.5000000000000004
R_2_30_5_2 Node2_30_5 Node2_31_5 2.5000000000000004
R_2_30_5_3 Node2_30_5 GND 706560.0000000001
R_2_30_6_1 Node2_30_6 Node2_30_7 2.5000000000000004
R_2_30_6_2 Node2_30_6 Node2_31_6 2.5000000000000004
R_2_30_6_3 Node2_30_6 GND 706560.0000000001
R_2_30_7_1 Node2_30_7 Node2_30_8 2.5000000000000004
R_2_30_7_2 Node2_30_7 Node2_31_7 2.5000000000000004
R_2_30_7_3 Node2_30_7 GND 706560.0000000001
R_2_30_8_1 Node2_30_8 Node2_30_9 2.5000000000000004
R_2_30_8_2 Node2_30_8 Node2_31_8 2.5000000000000004
R_2_30_8_3 Node2_30_8 GND 706560.0000000001
R_2_30_9_1 Node2_30_9 Node2_30_10 2.5000000000000004
R_2_30_9_2 Node2_30_9 Node2_31_9 2.5000000000000004
R_2_30_9_3 Node2_30_9 GND 706560.0000000001
R_2_30_10_1 Node2_30_10 Node2_30_11 2.5000000000000004
R_2_30_10_2 Node2_30_10 Node2_31_10 2.5000000000000004
R_2_30_10_3 Node2_30_10 GND 706560.0000000001
R_2_30_11_1 Node2_30_11 Node2_30_12 2.5000000000000004
R_2_30_11_2 Node2_30_11 Node2_31_11 2.5000000000000004
R_2_30_11_3 Node2_30_11 GND 706560.0000000001
R_2_30_12_1 Node2_30_12 Node2_30_13 2.5000000000000004
R_2_30_12_2 Node2_30_12 Node2_31_12 2.5000000000000004
R_2_30_12_3 Node2_30_12 GND 706560.0000000001
R_2_30_13_1 Node2_30_13 Node2_30_14 2.5000000000000004
R_2_30_13_2 Node2_30_13 Node2_31_13 2.5000000000000004
R_2_30_13_3 Node2_30_13 GND 706560.0000000001
R_2_30_14_1 Node2_30_14 Node2_30_15 2.5000000000000004
R_2_30_14_2 Node2_30_14 Node2_31_14 2.5000000000000004
R_2_30_14_3 Node2_30_14 GND 706560.0000000001
R_2_30_15_1 Node2_30_15 Node2_30_16 2.5000000000000004
R_2_30_15_2 Node2_30_15 Node2_31_15 2.5000000000000004
R_2_30_15_3 Node2_30_15 GND 706560.0000000001
R_2_30_16_1 Node2_30_16 Node2_30_17 2.5000000000000004
R_2_30_16_2 Node2_30_16 Node2_31_16 2.5000000000000004
R_2_30_16_3 Node2_30_16 GND 706560.0000000001
R_2_30_17_1 Node2_30_17 Node2_30_18 2.5000000000000004
R_2_30_17_2 Node2_30_17 Node2_31_17 2.5000000000000004
R_2_30_17_3 Node2_30_17 GND 706560.0000000001
R_2_30_18_1 Node2_30_18 Node2_30_19 2.5000000000000004
R_2_30_18_2 Node2_30_18 Node2_31_18 2.5000000000000004
R_2_30_18_3 Node2_30_18 GND 706560.0000000001
R_2_30_19_1 Node2_30_19 Node2_30_20 2.5000000000000004
R_2_30_19_2 Node2_30_19 Node2_31_19 2.5000000000000004
R_2_30_19_3 Node2_30_19 GND 706560.0000000001
R_2_30_20_1 Node2_30_20 Node2_30_21 2.5000000000000004
R_2_30_20_2 Node2_30_20 Node2_31_20 2.5000000000000004
R_2_30_20_3 Node2_30_20 GND 706560.0000000001
R_2_30_21_1 Node2_30_21 Node2_30_22 2.5000000000000004
R_2_30_21_2 Node2_30_21 Node2_31_21 2.5000000000000004
R_2_30_21_3 Node2_30_21 GND 706560.0000000001
R_2_30_22_1 Node2_30_22 Node2_30_23 2.5000000000000004
R_2_30_22_2 Node2_30_22 Node2_31_22 2.5000000000000004
R_2_30_22_3 Node2_30_22 GND 706560.0000000001
R_2_30_23_1 Node2_30_23 Node2_30_24 2.5000000000000004
R_2_30_23_2 Node2_30_23 Node2_31_23 2.5000000000000004
R_2_30_23_3 Node2_30_23 GND 706560.0000000001
R_2_30_24_1 Node2_30_24 Node2_30_25 2.5000000000000004
R_2_30_24_2 Node2_30_24 Node2_31_24 2.5000000000000004
R_2_30_24_3 Node2_30_24 GND 706560.0000000001
R_2_30_25_1 Node2_30_25 Node2_30_26 2.5000000000000004
R_2_30_25_2 Node2_30_25 Node2_31_25 2.5000000000000004
R_2_30_25_3 Node2_30_25 GND 706560.0000000001
R_2_30_26_1 Node2_30_26 Node2_30_27 2.5000000000000004
R_2_30_26_2 Node2_30_26 Node2_31_26 2.5000000000000004
R_2_30_26_3 Node2_30_26 GND 706560.0000000001
R_2_30_27_1 Node2_30_27 Node2_30_28 2.5000000000000004
R_2_30_27_2 Node2_30_27 Node2_31_27 2.5000000000000004
R_2_30_27_3 Node2_30_27 GND 706560.0000000001
R_2_30_28_1 Node2_30_28 Node2_30_29 2.5000000000000004
R_2_30_28_2 Node2_30_28 Node2_31_28 2.5000000000000004
R_2_30_28_3 Node2_30_28 GND 706560.0000000001
R_2_30_29_1 Node2_30_29 Node2_30_30 2.5000000000000004
R_2_30_29_2 Node2_30_29 Node2_31_29 2.5000000000000004
R_2_30_29_3 Node2_30_29 GND 706560.0000000001
R_2_30_30_1 Node2_30_30 Node2_30_31 2.5000000000000004
R_2_30_30_2 Node2_30_30 Node2_31_30 2.5000000000000004
R_2_30_30_3 Node2_30_30 GND 706560.0000000001
Rhs_2_30_31_1 Node2_30_31 Node_hs_right 71.54069767441861
R_2_30_31_2 Node2_30_31 Node2_31_31 2.5000000000000004
R_2_30_31_3 Node2_30_31 GND 706560.0000000001
R_2_31_0_1 Node2_31_0 Node2_31_1 2.5000000000000004
Rhs_2_31_0_1 Node2_31_0 Node_hs_right 71.54069767441861
Rhs_2_31_0_2 Node2_31_0 Node_hs_top 71.54069767441861
R_2_31_0_3 Node2_31_0 GND 706560.0000000001
R_2_31_1_1 Node2_31_1 Node2_31_2 2.5000000000000004
Rhs_2_31_1_2 Node2_31_1 Node_hs_top 71.54069767441861
R_2_31_1_3 Node2_31_1 GND 706560.0000000001
R_2_31_2_1 Node2_31_2 Node2_31_3 2.5000000000000004
Rhs_2_31_2_2 Node2_31_2 Node_hs_top 71.54069767441861
R_2_31_2_3 Node2_31_2 GND 706560.0000000001
R_2_31_3_1 Node2_31_3 Node2_31_4 2.5000000000000004
Rhs_2_31_3_2 Node2_31_3 Node_hs_top 71.54069767441861
R_2_31_3_3 Node2_31_3 GND 706560.0000000001
R_2_31_4_1 Node2_31_4 Node2_31_5 2.5000000000000004
Rhs_2_31_4_2 Node2_31_4 Node_hs_top 71.54069767441861
R_2_31_4_3 Node2_31_4 GND 706560.0000000001
R_2_31_5_1 Node2_31_5 Node2_31_6 2.5000000000000004
Rhs_2_31_5_2 Node2_31_5 Node_hs_top 71.54069767441861
R_2_31_5_3 Node2_31_5 GND 706560.0000000001
R_2_31_6_1 Node2_31_6 Node2_31_7 2.5000000000000004
Rhs_2_31_6_2 Node2_31_6 Node_hs_top 71.54069767441861
R_2_31_6_3 Node2_31_6 GND 706560.0000000001
R_2_31_7_1 Node2_31_7 Node2_31_8 2.5000000000000004
Rhs_2_31_7_2 Node2_31_7 Node_hs_top 71.54069767441861
R_2_31_7_3 Node2_31_7 GND 706560.0000000001
R_2_31_8_1 Node2_31_8 Node2_31_9 2.5000000000000004
Rhs_2_31_8_2 Node2_31_8 Node_hs_top 71.54069767441861
R_2_31_8_3 Node2_31_8 GND 706560.0000000001
R_2_31_9_1 Node2_31_9 Node2_31_10 2.5000000000000004
Rhs_2_31_9_2 Node2_31_9 Node_hs_top 71.54069767441861
R_2_31_9_3 Node2_31_9 GND 706560.0000000001
R_2_31_10_1 Node2_31_10 Node2_31_11 2.5000000000000004
Rhs_2_31_10_2 Node2_31_10 Node_hs_top 71.54069767441861
R_2_31_10_3 Node2_31_10 GND 706560.0000000001
R_2_31_11_1 Node2_31_11 Node2_31_12 2.5000000000000004
Rhs_2_31_11_2 Node2_31_11 Node_hs_top 71.54069767441861
R_2_31_11_3 Node2_31_11 GND 706560.0000000001
R_2_31_12_1 Node2_31_12 Node2_31_13 2.5000000000000004
Rhs_2_31_12_2 Node2_31_12 Node_hs_top 71.54069767441861
R_2_31_12_3 Node2_31_12 GND 706560.0000000001
R_2_31_13_1 Node2_31_13 Node2_31_14 2.5000000000000004
Rhs_2_31_13_2 Node2_31_13 Node_hs_top 71.54069767441861
R_2_31_13_3 Node2_31_13 GND 706560.0000000001
R_2_31_14_1 Node2_31_14 Node2_31_15 2.5000000000000004
Rhs_2_31_14_2 Node2_31_14 Node_hs_top 71.54069767441861
R_2_31_14_3 Node2_31_14 GND 706560.0000000001
R_2_31_15_1 Node2_31_15 Node2_31_16 2.5000000000000004
Rhs_2_31_15_2 Node2_31_15 Node_hs_top 71.54069767441861
R_2_31_15_3 Node2_31_15 GND 706560.0000000001
R_2_31_16_1 Node2_31_16 Node2_31_17 2.5000000000000004
Rhs_2_31_16_2 Node2_31_16 Node_hs_top 71.54069767441861
R_2_31_16_3 Node2_31_16 GND 706560.0000000001
R_2_31_17_1 Node2_31_17 Node2_31_18 2.5000000000000004
Rhs_2_31_17_2 Node2_31_17 Node_hs_top 71.54069767441861
R_2_31_17_3 Node2_31_17 GND 706560.0000000001
R_2_31_18_1 Node2_31_18 Node2_31_19 2.5000000000000004
Rhs_2_31_18_2 Node2_31_18 Node_hs_top 71.54069767441861
R_2_31_18_3 Node2_31_18 GND 706560.0000000001
R_2_31_19_1 Node2_31_19 Node2_31_20 2.5000000000000004
Rhs_2_31_19_2 Node2_31_19 Node_hs_top 71.54069767441861
R_2_31_19_3 Node2_31_19 GND 706560.0000000001
R_2_31_20_1 Node2_31_20 Node2_31_21 2.5000000000000004
Rhs_2_31_20_2 Node2_31_20 Node_hs_top 71.54069767441861
R_2_31_20_3 Node2_31_20 GND 706560.0000000001
R_2_31_21_1 Node2_31_21 Node2_31_22 2.5000000000000004
Rhs_2_31_21_2 Node2_31_21 Node_hs_top 71.54069767441861
R_2_31_21_3 Node2_31_21 GND 706560.0000000001
R_2_31_22_1 Node2_31_22 Node2_31_23 2.5000000000000004
Rhs_2_31_22_2 Node2_31_22 Node_hs_top 71.54069767441861
R_2_31_22_3 Node2_31_22 GND 706560.0000000001
R_2_31_23_1 Node2_31_23 Node2_31_24 2.5000000000000004
Rhs_2_31_23_2 Node2_31_23 Node_hs_top 71.54069767441861
R_2_31_23_3 Node2_31_23 GND 706560.0000000001
R_2_31_24_1 Node2_31_24 Node2_31_25 2.5000000000000004
Rhs_2_31_24_2 Node2_31_24 Node_hs_top 71.54069767441861
R_2_31_24_3 Node2_31_24 GND 706560.0000000001
R_2_31_25_1 Node2_31_25 Node2_31_26 2.5000000000000004
Rhs_2_31_25_2 Node2_31_25 Node_hs_top 71.54069767441861
R_2_31_25_3 Node2_31_25 GND 706560.0000000001
R_2_31_26_1 Node2_31_26 Node2_31_27 2.5000000000000004
Rhs_2_31_26_2 Node2_31_26 Node_hs_top 71.54069767441861
R_2_31_26_3 Node2_31_26 GND 706560.0000000001
R_2_31_27_1 Node2_31_27 Node2_31_28 2.5000000000000004
Rhs_2_31_27_2 Node2_31_27 Node_hs_top 71.54069767441861
R_2_31_27_3 Node2_31_27 GND 706560.0000000001
R_2_31_28_1 Node2_31_28 Node2_31_29 2.5000000000000004
Rhs_2_31_28_2 Node2_31_28 Node_hs_top 71.54069767441861
R_2_31_28_3 Node2_31_28 GND 706560.0000000001
R_2_31_29_1 Node2_31_29 Node2_31_30 2.5000000000000004
Rhs_2_31_29_2 Node2_31_29 Node_hs_top 71.54069767441861
R_2_31_29_3 Node2_31_29 GND 706560.0000000001
R_2_31_30_1 Node2_31_30 Node2_31_31 2.5000000000000004
Rhs_2_31_30_2 Node2_31_30 Node_hs_top 71.54069767441861
R_2_31_30_3 Node2_31_30 GND 706560.0000000001
Rhs_2_31_31_1 Node2_31_31 Node_hs_right 71.54069767441861
Rhs_2_31_31_2 Node2_31_31 Node_hs_top 71.54069767441861
R_2_31_31_3 Node2_31_31 GND 706560.0000000001
R_sp_hs_in_left Node_sp_left Node_hs_in_left 0.025015634771732333
R_sp_hs_in_right Node_sp_right Node_hs_in_right 0.025015634771732333
R_sp_hs_in_top Node_sp_top Node_hs_in_top 0.025015634771732333
R_sp_hs_in_bot Node_sp_bot Node_hs_in_bot 0.025015634771732333
R_hs_hs_left Node_hs_in_left Node_hs_out_left 1.3057851239669422
R_hs_hs_right Node_hs_in_right Node_hs_out_right 1.3057851239669422
R_hs_hs_top Node_hs_in_top Node_hs_out_top 1.3057851239669422
R_hs_hs_bot Node_hs_in_bot Node_hs_out_bot 1.3057851239669422
R_hs_amb_in_left Node_hs_in_left GND 1.6260162601626016
R_hs_amb_in_right Node_hs_in_right GND 1.6260162601626016
R_hs_amb_in_top Node_hs_in_top GND 1.6260162601626016
R_hs_amb_in_bot Node_hs_in_bot GND 1.6260162601626016
R_hs_amb_out_left Node_hs_out_left GND 0.5416666666666666
R_hs_amb_out_right Node_hs_out_right GND 0.5416666666666666
R_hs_amb_out_top Node_hs_out_top GND 0.5416666666666666
R_hs_amb_out_bot Node_hs_out_bot GND 0.5416666666666666
.OP
.OPTIONS LINSOL TYPE=KLU
.PRINT DC FORMAT=CSV PRECISION=4 V(Node0_0_0) V(Node0_0_1) V(Node0_0_2) V(Node0_0_3) V(Node0_0_4) V(Node0_0_5) V(Node0_0_6) V(Node0_0_7) V(Node0_0_8) V(Node0_0_9) V(Node0_0_10) V(Node0_0_11) V(Node0_0_12) V(Node0_0_13) V(Node0_0_14) V(Node0_0_15) V(Node0_0_16) V(Node0_0_17) V(Node0_0_18) V(Node0_0_19) V(Node0_0_20) V(Node0_0_21) V(Node0_0_22) V(Node0_0_23) V(Node0_0_24) V(Node0_0_25) V(Node0_0_26) V(Node0_0_27) V(Node0_0_28) V(Node0_0_29) V(Node0_0_30) V(Node0_0_31) V(Node0_1_0) V(Node0_1_1) V(Node0_1_2) V(Node0_1_3) V(Node0_1_4) V(Node0_1_5) V(Node0_1_6) V(Node0_1_7) V(Node0_1_8) V(Node0_1_9) V(Node0_1_10) V(Node0_1_11) V(Node0_1_12) V(Node0_1_13) V(Node0_1_14) V(Node0_1_15) V(Node0_1_16) V(Node0_1_17) V(Node0_1_18) V(Node0_1_19) V(Node0_1_20) V(Node0_1_21) V(Node0_1_22) V(Node0_1_23) V(Node0_1_24) V(Node0_1_25) V(Node0_1_26) V(Node0_1_27) V(Node0_1_28) V(Node0_1_29) V(Node0_1_30) V(Node0_1_31) V(Node0_2_0) V(Node0_2_1) V(Node0_2_2) V(Node0_2_3) V(Node0_2_4) V(Node0_2_5) V(Node0_2_6) V(Node0_2_7) V(Node0_2_8) V(Node0_2_9) V(Node0_2_10) V(Node0_2_11) V(Node0_2_12) V(Node0_2_13) V(Node0_2_14) V(Node0_2_15) V(Node0_2_16) V(Node0_2_17) V(Node0_2_18) V(Node0_2_19) V(Node0_2_20) V(Node0_2_21) V(Node0_2_22) V(Node0_2_23) V(Node0_2_24) V(Node0_2_25) V(Node0_2_26) V(Node0_2_27) V(Node0_2_28) V(Node0_2_29) V(Node0_2_30) V(Node0_2_31) V(Node0_3_0) V(Node0_3_1) V(Node0_3_2) V(Node0_3_3) V(Node0_3_4) V(Node0_3_5) V(Node0_3_6) V(Node0_3_7) V(Node0_3_8) V(Node0_3_9) V(Node0_3_10) V(Node0_3_11) V(Node0_3_12) V(Node0_3_13) V(Node0_3_14) V(Node0_3_15) V(Node0_3_16) V(Node0_3_17) V(Node0_3_18) V(Node0_3_19) V(Node0_3_20) V(Node0_3_21) V(Node0_3_22) V(Node0_3_23) V(Node0_3_24) V(Node0_3_25) V(Node0_3_26) V(Node0_3_27) V(Node0_3_28) V(Node0_3_29) V(Node0_3_30) V(Node0_3_31) V(Node0_4_0) V(Node0_4_1) V(Node0_4_2) V(Node0_4_3) V(Node0_4_4) V(Node0_4_5) V(Node0_4_6) V(Node0_4_7) V(Node0_4_8) V(Node0_4_9) V(Node0_4_10) V(Node0_4_11) V(Node0_4_12) V(Node0_4_13) V(Node0_4_14) V(Node0_4_15) V(Node0_4_16) V(Node0_4_17) V(Node0_4_18) V(Node0_4_19) V(Node0_4_20) V(Node0_4_21) V(Node0_4_22) V(Node0_4_23) V(Node0_4_24) V(Node0_4_25) V(Node0_4_26) V(Node0_4_27) V(Node0_4_28) V(Node0_4_29) V(Node0_4_30) V(Node0_4_31) V(Node0_5_0) V(Node0_5_1) V(Node0_5_2) V(Node0_5_3) V(Node0_5_4) V(Node0_5_5) V(Node0_5_6) V(Node0_5_7) V(Node0_5_8) V(Node0_5_9) V(Node0_5_10) V(Node0_5_11) V(Node0_5_12) V(Node0_5_13) V(Node0_5_14) V(Node0_5_15) V(Node0_5_16) V(Node0_5_17) V(Node0_5_18) V(Node0_5_19) V(Node0_5_20) V(Node0_5_21) V(Node0_5_22) V(Node0_5_23) V(Node0_5_24) V(Node0_5_25) V(Node0_5_26) V(Node0_5_27) V(Node0_5_28) V(Node0_5_29) V(Node0_5_30) V(Node0_5_31) V(Node0_6_0) V(Node0_6_1) V(Node0_6_2) V(Node0_6_3) V(Node0_6_4) V(Node0_6_5) V(Node0_6_6) V(Node0_6_7) V(Node0_6_8) V(Node0_6_9) V(Node0_6_10) V(Node0_6_11) V(Node0_6_12) V(Node0_6_13) V(Node0_6_14) V(Node0_6_15) V(Node0_6_16) V(Node0_6_17) V(Node0_6_18) V(Node0_6_19) V(Node0_6_20) V(Node0_6_21) V(Node0_6_22) V(Node0_6_23) V(Node0_6_24) V(Node0_6_25) V(Node0_6_26) V(Node0_6_27) V(Node0_6_28) V(Node0_6_29) V(Node0_6_30) V(Node0_6_31) V(Node0_7_0) V(Node0_7_1) V(Node0_7_2) V(Node0_7_3) V(Node0_7_4) V(Node0_7_5) V(Node0_7_6) V(Node0_7_7) V(Node0_7_8) V(Node0_7_9) V(Node0_7_10) V(Node0_7_11) V(Node0_7_12) V(Node0_7_13) V(Node0_7_14) V(Node0_7_15) V(Node0_7_16) V(Node0_7_17) V(Node0_7_18) V(Node0_7_19) V(Node0_7_20) V(Node0_7_21) V(Node0_7_22) V(Node0_7_23) V(Node0_7_24) V(Node0_7_25) V(Node0_7_26) V(Node0_7_27) V(Node0_7_28) V(Node0_7_29) V(Node0_7_30) V(Node0_7_31) V(Node0_8_0) V(Node0_8_1) V(Node0_8_2) V(Node0_8_3) V(Node0_8_4) V(Node0_8_5) V(Node0_8_6) V(Node0_8_7) V(Node0_8_8) V(Node0_8_9) V(Node0_8_10) V(Node0_8_11) V(Node0_8_12) V(Node0_8_13) V(Node0_8_14) V(Node0_8_15) V(Node0_8_16) V(Node0_8_17) V(Node0_8_18) V(Node0_8_19) V(Node0_8_20) V(Node0_8_21) V(Node0_8_22) V(Node0_8_23) V(Node0_8_24) V(Node0_8_25) V(Node0_8_26) V(Node0_8_27) V(Node0_8_28) V(Node0_8_29) V(Node0_8_30) V(Node0_8_31) V(Node0_9_0) V(Node0_9_1) V(Node0_9_2) V(Node0_9_3) V(Node0_9_4) V(Node0_9_5) V(Node0_9_6) V(Node0_9_7) V(Node0_9_8) V(Node0_9_9) V(Node0_9_10) V(Node0_9_11) V(Node0_9_12) V(Node0_9_13) V(Node0_9_14) V(Node0_9_15) V(Node0_9_16) V(Node0_9_17) V(Node0_9_18) V(Node0_9_19) V(Node0_9_20) V(Node0_9_21) V(Node0_9_22) V(Node0_9_23) V(Node0_9_24) V(Node0_9_25) V(Node0_9_26) V(Node0_9_27) V(Node0_9_28) V(Node0_9_29) V(Node0_9_30) V(Node0_9_31) V(Node0_10_0) V(Node0_10_1) V(Node0_10_2) V(Node0_10_3) V(Node0_10_4) V(Node0_10_5) V(Node0_10_6) V(Node0_10_7) V(Node0_10_8) V(Node0_10_9) V(Node0_10_10) V(Node0_10_11) V(Node0_10_12) V(Node0_10_13) V(Node0_10_14) V(Node0_10_15) V(Node0_10_16) V(Node0_10_17) V(Node0_10_18) V(Node0_10_19) V(Node0_10_20) V(Node0_10_21) V(Node0_10_22) V(Node0_10_23) V(Node0_10_24) V(Node0_10_25) V(Node0_10_26) V(Node0_10_27) V(Node0_10_28) V(Node0_10_29) V(Node0_10_30) V(Node0_10_31) V(Node0_11_0) V(Node0_11_1) V(Node0_11_2) V(Node0_11_3) V(Node0_11_4) V(Node0_11_5) V(Node0_11_6) V(Node0_11_7) V(Node0_11_8) V(Node0_11_9) V(Node0_11_10) V(Node0_11_11) V(Node0_11_12) V(Node0_11_13) V(Node0_11_14) V(Node0_11_15) V(Node0_11_16) V(Node0_11_17) V(Node0_11_18) V(Node0_11_19) V(Node0_11_20) V(Node0_11_21) V(Node0_11_22) V(Node0_11_23) V(Node0_11_24) V(Node0_11_25) V(Node0_11_26) V(Node0_11_27) V(Node0_11_28) V(Node0_11_29) V(Node0_11_30) V(Node0_11_31) V(Node0_12_0) V(Node0_12_1) V(Node0_12_2) V(Node0_12_3) V(Node0_12_4) V(Node0_12_5) V(Node0_12_6) V(Node0_12_7) V(Node0_12_8) V(Node0_12_9) V(Node0_12_10) V(Node0_12_11) V(Node0_12_12) V(Node0_12_13) V(Node0_12_14) V(Node0_12_15) V(Node0_12_16) V(Node0_12_17) V(Node0_12_18) V(Node0_12_19) V(Node0_12_20) V(Node0_12_21) V(Node0_12_22) V(Node0_12_23) V(Node0_12_24) V(Node0_12_25) V(Node0_12_26) V(Node0_12_27) V(Node0_12_28) V(Node0_12_29) V(Node0_12_30) V(Node0_12_31) V(Node0_13_0) V(Node0_13_1) V(Node0_13_2) V(Node0_13_3) V(Node0_13_4) V(Node0_13_5) V(Node0_13_6) V(Node0_13_7) V(Node0_13_8) V(Node0_13_9) V(Node0_13_10) V(Node0_13_11) V(Node0_13_12) V(Node0_13_13) V(Node0_13_14) V(Node0_13_15) V(Node0_13_16) V(Node0_13_17) V(Node0_13_18) V(Node0_13_19) V(Node0_13_20) V(Node0_13_21) V(Node0_13_22) V(Node0_13_23) V(Node0_13_24) V(Node0_13_25) V(Node0_13_26) V(Node0_13_27) V(Node0_13_28) V(Node0_13_29) V(Node0_13_30) V(Node0_13_31) V(Node0_14_0) V(Node0_14_1) V(Node0_14_2) V(Node0_14_3) V(Node0_14_4) V(Node0_14_5) V(Node0_14_6) V(Node0_14_7) V(Node0_14_8) V(Node0_14_9) V(Node0_14_10) V(Node0_14_11) V(Node0_14_12) V(Node0_14_13) V(Node0_14_14) V(Node0_14_15) V(Node0_14_16) V(Node0_14_17) V(Node0_14_18) V(Node0_14_19) V(Node0_14_20) V(Node0_14_21) V(Node0_14_22) V(Node0_14_23) V(Node0_14_24) V(Node0_14_25) V(Node0_14_26) V(Node0_14_27) V(Node0_14_28) V(Node0_14_29) V(Node0_14_30) V(Node0_14_31) V(Node0_15_0) V(Node0_15_1) V(Node0_15_2) V(Node0_15_3) V(Node0_15_4) V(Node0_15_5) V(Node0_15_6) V(Node0_15_7) V(Node0_15_8) V(Node0_15_9) V(Node0_15_10) V(Node0_15_11) V(Node0_15_12) V(Node0_15_13) V(Node0_15_14) V(Node0_15_15) V(Node0_15_16) V(Node0_15_17) V(Node0_15_18) V(Node0_15_19) V(Node0_15_20) V(Node0_15_21) V(Node0_15_22) V(Node0_15_23) V(Node0_15_24) V(Node0_15_25) V(Node0_15_26) V(Node0_15_27) V(Node0_15_28) V(Node0_15_29) V(Node0_15_30) V(Node0_15_31) V(Node0_16_0) V(Node0_16_1) V(Node0_16_2) V(Node0_16_3) V(Node0_16_4) V(Node0_16_5) V(Node0_16_6) V(Node0_16_7) V(Node0_16_8) V(Node0_16_9) V(Node0_16_10) V(Node0_16_11) V(Node0_16_12) V(Node0_16_13) V(Node0_16_14) V(Node0_16_15) V(Node0_16_16) V(Node0_16_17) V(Node0_16_18) V(Node0_16_19) V(Node0_16_20) V(Node0_16_21) V(Node0_16_22) V(Node0_16_23) V(Node0_16_24) V(Node0_16_25) V(Node0_16_26) V(Node0_16_27) V(Node0_16_28) V(Node0_16_29) V(Node0_16_30) V(Node0_16_31) V(Node0_17_0) V(Node0_17_1) V(Node0_17_2) V(Node0_17_3) V(Node0_17_4) V(Node0_17_5) V(Node0_17_6) V(Node0_17_7) V(Node0_17_8) V(Node0_17_9) V(Node0_17_10) V(Node0_17_11) V(Node0_17_12) V(Node0_17_13) V(Node0_17_14) V(Node0_17_15) V(Node0_17_16) V(Node0_17_17) V(Node0_17_18) V(Node0_17_19) V(Node0_17_20) V(Node0_17_21) V(Node0_17_22) V(Node0_17_23) V(Node0_17_24) V(Node0_17_25) V(Node0_17_26) V(Node0_17_27) V(Node0_17_28) V(Node0_17_29) V(Node0_17_30) V(Node0_17_31) V(Node0_18_0) V(Node0_18_1) V(Node0_18_2) V(Node0_18_3) V(Node0_18_4) V(Node0_18_5) V(Node0_18_6) V(Node0_18_7) V(Node0_18_8) V(Node0_18_9) V(Node0_18_10) V(Node0_18_11) V(Node0_18_12) V(Node0_18_13) V(Node0_18_14) V(Node0_18_15) V(Node0_18_16) V(Node0_18_17) V(Node0_18_18) V(Node0_18_19) V(Node0_18_20) V(Node0_18_21) V(Node0_18_22) V(Node0_18_23) V(Node0_18_24) V(Node0_18_25) V(Node0_18_26) V(Node0_18_27) V(Node0_18_28) V(Node0_18_29) V(Node0_18_30) V(Node0_18_31) V(Node0_19_0) V(Node0_19_1) V(Node0_19_2) V(Node0_19_3) V(Node0_19_4) V(Node0_19_5) V(Node0_19_6) V(Node0_19_7) V(Node0_19_8) V(Node0_19_9) V(Node0_19_10) V(Node0_19_11) V(Node0_19_12) V(Node0_19_13) V(Node0_19_14) V(Node0_19_15) V(Node0_19_16) V(Node0_19_17) V(Node0_19_18) V(Node0_19_19) V(Node0_19_20) V(Node0_19_21) V(Node0_19_22) V(Node0_19_23) V(Node0_19_24) V(Node0_19_25) V(Node0_19_26) V(Node0_19_27) V(Node0_19_28) V(Node0_19_29) V(Node0_19_30) V(Node0_19_31) V(Node0_20_0) V(Node0_20_1) V(Node0_20_2) V(Node0_20_3) V(Node0_20_4) V(Node0_20_5) V(Node0_20_6) V(Node0_20_7) V(Node0_20_8) V(Node0_20_9) V(Node0_20_10) V(Node0_20_11) V(Node0_20_12) V(Node0_20_13) V(Node0_20_14) V(Node0_20_15) V(Node0_20_16) V(Node0_20_17) V(Node0_20_18) V(Node0_20_19) V(Node0_20_20) V(Node0_20_21) V(Node0_20_22) V(Node0_20_23) V(Node0_20_24) V(Node0_20_25) V(Node0_20_26) V(Node0_20_27) V(Node0_20_28) V(Node0_20_29) V(Node0_20_30) V(Node0_20_31) V(Node0_21_0) V(Node0_21_1) V(Node0_21_2) V(Node0_21_3) V(Node0_21_4) V(Node0_21_5) V(Node0_21_6) V(Node0_21_7) V(Node0_21_8) V(Node0_21_9) V(Node0_21_10) V(Node0_21_11) V(Node0_21_12) V(Node0_21_13) V(Node0_21_14) V(Node0_21_15) V(Node0_21_16) V(Node0_21_17) V(Node0_21_18) V(Node0_21_19) V(Node0_21_20) V(Node0_21_21) V(Node0_21_22) V(Node0_21_23) V(Node0_21_24) V(Node0_21_25) V(Node0_21_26) V(Node0_21_27) V(Node0_21_28) V(Node0_21_29) V(Node0_21_30) V(Node0_21_31) V(Node0_22_0) V(Node0_22_1) V(Node0_22_2) V(Node0_22_3) V(Node0_22_4) V(Node0_22_5) V(Node0_22_6) V(Node0_22_7) V(Node0_22_8) V(Node0_22_9) V(Node0_22_10) V(Node0_22_11) V(Node0_22_12) V(Node0_22_13) V(Node0_22_14) V(Node0_22_15) V(Node0_22_16) V(Node0_22_17) V(Node0_22_18) V(Node0_22_19) V(Node0_22_20) V(Node0_22_21) V(Node0_22_22) V(Node0_22_23) V(Node0_22_24) V(Node0_22_25) V(Node0_22_26) V(Node0_22_27) V(Node0_22_28) V(Node0_22_29) V(Node0_22_30) V(Node0_22_31) V(Node0_23_0) V(Node0_23_1) V(Node0_23_2) V(Node0_23_3) V(Node0_23_4) V(Node0_23_5) V(Node0_23_6) V(Node0_23_7) V(Node0_23_8) V(Node0_23_9) V(Node0_23_10) V(Node0_23_11) V(Node0_23_12) V(Node0_23_13) V(Node0_23_14) V(Node0_23_15) V(Node0_23_16) V(Node0_23_17) V(Node0_23_18) V(Node0_23_19) V(Node0_23_20) V(Node0_23_21) V(Node0_23_22) V(Node0_23_23) V(Node0_23_24) V(Node0_23_25) V(Node0_23_26) V(Node0_23_27) V(Node0_23_28) V(Node0_23_29) V(Node0_23_30) V(Node0_23_31) V(Node0_24_0) V(Node0_24_1) V(Node0_24_2) V(Node0_24_3) V(Node0_24_4) V(Node0_24_5) V(Node0_24_6) V(Node0_24_7) V(Node0_24_8) V(Node0_24_9) V(Node0_24_10) V(Node0_24_11) V(Node0_24_12) V(Node0_24_13) V(Node0_24_14) V(Node0_24_15) V(Node0_24_16) V(Node0_24_17) V(Node0_24_18) V(Node0_24_19) V(Node0_24_20) V(Node0_24_21) V(Node0_24_22) V(Node0_24_23) V(Node0_24_24) V(Node0_24_25) V(Node0_24_26) V(Node0_24_27) V(Node0_24_28) V(Node0_24_29) V(Node0_24_30) V(Node0_24_31) V(Node0_25_0) V(Node0_25_1) V(Node0_25_2) V(Node0_25_3) V(Node0_25_4) V(Node0_25_5) V(Node0_25_6) V(Node0_25_7) V(Node0_25_8) V(Node0_25_9) V(Node0_25_10) V(Node0_25_11) V(Node0_25_12) V(Node0_25_13) V(Node0_25_14) V(Node0_25_15) V(Node0_25_16) V(Node0_25_17) V(Node0_25_18) V(Node0_25_19) V(Node0_25_20) V(Node0_25_21) V(Node0_25_22) V(Node0_25_23) V(Node0_25_24) V(Node0_25_25) V(Node0_25_26) V(Node0_25_27) V(Node0_25_28) V(Node0_25_29) V(Node0_25_30) V(Node0_25_31) V(Node0_26_0) V(Node0_26_1) V(Node0_26_2) V(Node0_26_3) V(Node0_26_4) V(Node0_26_5) V(Node0_26_6) V(Node0_26_7) V(Node0_26_8) V(Node0_26_9) V(Node0_26_10) V(Node0_26_11) V(Node0_26_12) V(Node0_26_13) V(Node0_26_14) V(Node0_26_15) V(Node0_26_16) V(Node0_26_17) V(Node0_26_18) V(Node0_26_19) V(Node0_26_20) V(Node0_26_21) V(Node0_26_22) V(Node0_26_23) V(Node0_26_24) V(Node0_26_25) V(Node0_26_26) V(Node0_26_27) V(Node0_26_28) V(Node0_26_29) V(Node0_26_30) V(Node0_26_31) V(Node0_27_0) V(Node0_27_1) V(Node0_27_2) V(Node0_27_3) V(Node0_27_4) V(Node0_27_5) V(Node0_27_6) V(Node0_27_7) V(Node0_27_8) V(Node0_27_9) V(Node0_27_10) V(Node0_27_11) V(Node0_27_12) V(Node0_27_13) V(Node0_27_14) V(Node0_27_15) V(Node0_27_16) V(Node0_27_17) V(Node0_27_18) V(Node0_27_19) V(Node0_27_20) V(Node0_27_21) V(Node0_27_22) V(Node0_27_23) V(Node0_27_24) V(Node0_27_25) V(Node0_27_26) V(Node0_27_27) V(Node0_27_28) V(Node0_27_29) V(Node0_27_30) V(Node0_27_31) V(Node0_28_0) V(Node0_28_1) V(Node0_28_2) V(Node0_28_3) V(Node0_28_4) V(Node0_28_5) V(Node0_28_6) V(Node0_28_7) V(Node0_28_8) V(Node0_28_9) V(Node0_28_10) V(Node0_28_11) V(Node0_28_12) V(Node0_28_13) V(Node0_28_14) V(Node0_28_15) V(Node0_28_16) V(Node0_28_17) V(Node0_28_18) V(Node0_28_19) V(Node0_28_20) V(Node0_28_21) V(Node0_28_22) V(Node0_28_23) V(Node0_28_24) V(Node0_28_25) V(Node0_28_26) V(Node0_28_27) V(Node0_28_28) V(Node0_28_29) V(Node0_28_30) V(Node0_28_31) V(Node0_29_0) V(Node0_29_1) V(Node0_29_2) V(Node0_29_3) V(Node0_29_4) V(Node0_29_5) V(Node0_29_6) V(Node0_29_7) V(Node0_29_8) V(Node0_29_9) V(Node0_29_10) V(Node0_29_11) V(Node0_29_12) V(Node0_29_13) V(Node0_29_14) V(Node0_29_15) V(Node0_29_16) V(Node0_29_17) V(Node0_29_18) V(Node0_29_19) V(Node0_29_20) V(Node0_29_21) V(Node0_29_22) V(Node0_29_23) V(Node0_29_24) V(Node0_29_25) V(Node0_29_26) V(Node0_29_27) V(Node0_29_28) V(Node0_29_29) V(Node0_29_30) V(Node0_29_31) V(Node0_30_0) V(Node0_30_1) V(Node0_30_2) V(Node0_30_3) V(Node0_30_4) V(Node0_30_5) V(Node0_30_6) V(Node0_30_7) V(Node0_30_8) V(Node0_30_9) V(Node0_30_10) V(Node0_30_11) V(Node0_30_12) V(Node0_30_13) V(Node0_30_14) V(Node0_30_15) V(Node0_30_16) V(Node0_30_17) V(Node0_30_18) V(Node0_30_19) V(Node0_30_20) V(Node0_30_21) V(Node0_30_22) V(Node0_30_23) V(Node0_30_24) V(Node0_30_25) V(Node0_30_26) V(Node0_30_27) V(Node0_30_28) V(Node0_30_29) V(Node0_30_30) V(Node0_30_31) V(Node0_31_0) V(Node0_31_1) V(Node0_31_2) V(Node0_31_3) V(Node0_31_4) V(Node0_31_5) V(Node0_31_6) V(Node0_31_7) V(Node0_31_8) V(Node0_31_9) V(Node0_31_10) V(Node0_31_11) V(Node0_31_12) V(Node0_31_13) V(Node0_31_14) V(Node0_31_15) V(Node0_31_16) V(Node0_31_17) V(Node0_31_18) V(Node0_31_19) V(Node0_31_20) V(Node0_31_21) V(Node0_31_22) V(Node0_31_23) V(Node0_31_24) V(Node0_31_25) V(Node0_31_26) V(Node0_31_27) V(Node0_31_28) V(Node0_31_29) V(Node0_31_30) V(Node0_31_31) V(Node1_0_0) V(Node1_0_1) V(Node1_0_2) V(Node1_0_3) V(Node1_0_4) V(Node1_0_5) V(Node1_0_6) V(Node1_0_7) V(Node1_0_8) V(Node1_0_9) V(Node1_0_10) V(Node1_0_11) V(Node1_0_12) V(Node1_0_13) V(Node1_0_14) V(Node1_0_15) V(Node1_0_16) V(Node1_0_17) V(Node1_0_18) V(Node1_0_19) V(Node1_0_20) V(Node1_0_21) V(Node1_0_22) V(Node1_0_23) V(Node1_0_24) V(Node1_0_25) V(Node1_0_26) V(Node1_0_27) V(Node1_0_28) V(Node1_0_29) V(Node1_0_30) V(Node1_0_31) V(Node1_1_0) V(Node1_1_1) V(Node1_1_2) V(Node1_1_3) V(Node1_1_4) V(Node1_1_5) V(Node1_1_6) V(Node1_1_7) V(Node1_1_8) V(Node1_1_9) V(Node1_1_10) V(Node1_1_11) V(Node1_1_12) V(Node1_1_13) V(Node1_1_14) V(Node1_1_15) V(Node1_1_16) V(Node1_1_17) V(Node1_1_18) V(Node1_1_19) V(Node1_1_20) V(Node1_1_21) V(Node1_1_22) V(Node1_1_23) V(Node1_1_24) V(Node1_1_25) V(Node1_1_26) V(Node1_1_27) V(Node1_1_28) V(Node1_1_29) V(Node1_1_30) V(Node1_1_31) V(Node1_2_0) V(Node1_2_1) V(Node1_2_2) V(Node1_2_3) V(Node1_2_4) V(Node1_2_5) V(Node1_2_6) V(Node1_2_7) V(Node1_2_8) V(Node1_2_9) V(Node1_2_10) V(Node1_2_11) V(Node1_2_12) V(Node1_2_13) V(Node1_2_14) V(Node1_2_15) V(Node1_2_16) V(Node1_2_17) V(Node1_2_18) V(Node1_2_19) V(Node1_2_20) V(Node1_2_21) V(Node1_2_22) V(Node1_2_23) V(Node1_2_24) V(Node1_2_25) V(Node1_2_26) V(Node1_2_27) V(Node1_2_28) V(Node1_2_29) V(Node1_2_30) V(Node1_2_31) V(Node1_3_0) V(Node1_3_1) V(Node1_3_2) V(Node1_3_3) V(Node1_3_4) V(Node1_3_5) V(Node1_3_6) V(Node1_3_7) V(Node1_3_8) V(Node1_3_9) V(Node1_3_10) V(Node1_3_11) V(Node1_3_12) V(Node1_3_13) V(Node1_3_14) V(Node1_3_15) V(Node1_3_16) V(Node1_3_17) V(Node1_3_18) V(Node1_3_19) V(Node1_3_20) V(Node1_3_21) V(Node1_3_22) V(Node1_3_23) V(Node1_3_24) V(Node1_3_25) V(Node1_3_26) V(Node1_3_27) V(Node1_3_28) V(Node1_3_29) V(Node1_3_30) V(Node1_3_31) V(Node1_4_0) V(Node1_4_1) V(Node1_4_2) V(Node1_4_3) V(Node1_4_4) V(Node1_4_5) V(Node1_4_6) V(Node1_4_7) V(Node1_4_8) V(Node1_4_9) V(Node1_4_10) V(Node1_4_11) V(Node1_4_12) V(Node1_4_13) V(Node1_4_14) V(Node1_4_15) V(Node1_4_16) V(Node1_4_17) V(Node1_4_18) V(Node1_4_19) V(Node1_4_20) V(Node1_4_21) V(Node1_4_22) V(Node1_4_23) V(Node1_4_24) V(Node1_4_25) V(Node1_4_26) V(Node1_4_27) V(Node1_4_28) V(Node1_4_29) V(Node1_4_30) V(Node1_4_31) V(Node1_5_0) V(Node1_5_1) V(Node1_5_2) V(Node1_5_3) V(Node1_5_4) V(Node1_5_5) V(Node1_5_6) V(Node1_5_7) V(Node1_5_8) V(Node1_5_9) V(Node1_5_10) V(Node1_5_11) V(Node1_5_12) V(Node1_5_13) V(Node1_5_14) V(Node1_5_15) V(Node1_5_16) V(Node1_5_17) V(Node1_5_18) V(Node1_5_19) V(Node1_5_20) V(Node1_5_21) V(Node1_5_22) V(Node1_5_23) V(Node1_5_24) V(Node1_5_25) V(Node1_5_26) V(Node1_5_27) V(Node1_5_28) V(Node1_5_29) V(Node1_5_30) V(Node1_5_31) V(Node1_6_0) V(Node1_6_1) V(Node1_6_2) V(Node1_6_3) V(Node1_6_4) V(Node1_6_5) V(Node1_6_6) V(Node1_6_7) V(Node1_6_8) V(Node1_6_9) V(Node1_6_10) V(Node1_6_11) V(Node1_6_12) V(Node1_6_13) V(Node1_6_14) V(Node1_6_15) V(Node1_6_16) V(Node1_6_17) V(Node1_6_18) V(Node1_6_19) V(Node1_6_20) V(Node1_6_21) V(Node1_6_22) V(Node1_6_23) V(Node1_6_24) V(Node1_6_25) V(Node1_6_26) V(Node1_6_27) V(Node1_6_28) V(Node1_6_29) V(Node1_6_30) V(Node1_6_31) V(Node1_7_0) V(Node1_7_1) V(Node1_7_2) V(Node1_7_3) V(Node1_7_4) V(Node1_7_5) V(Node1_7_6) V(Node1_7_7) V(Node1_7_8) V(Node1_7_9) V(Node1_7_10) V(Node1_7_11) V(Node1_7_12) V(Node1_7_13) V(Node1_7_14) V(Node1_7_15) V(Node1_7_16) V(Node1_7_17) V(Node1_7_18) V(Node1_7_19) V(Node1_7_20) V(Node1_7_21) V(Node1_7_22) V(Node1_7_23) V(Node1_7_24) V(Node1_7_25) V(Node1_7_26) V(Node1_7_27) V(Node1_7_28) V(Node1_7_29) V(Node1_7_30) V(Node1_7_31) V(Node1_8_0) V(Node1_8_1) V(Node1_8_2) V(Node1_8_3) V(Node1_8_4) V(Node1_8_5) V(Node1_8_6) V(Node1_8_7) V(Node1_8_8) V(Node1_8_9) V(Node1_8_10) V(Node1_8_11) V(Node1_8_12) V(Node1_8_13) V(Node1_8_14) V(Node1_8_15) V(Node1_8_16) V(Node1_8_17) V(Node1_8_18) V(Node1_8_19) V(Node1_8_20) V(Node1_8_21) V(Node1_8_22) V(Node1_8_23) V(Node1_8_24) V(Node1_8_25) V(Node1_8_26) V(Node1_8_27) V(Node1_8_28) V(Node1_8_29) V(Node1_8_30) V(Node1_8_31) V(Node1_9_0) V(Node1_9_1) V(Node1_9_2) V(Node1_9_3) V(Node1_9_4) V(Node1_9_5) V(Node1_9_6) V(Node1_9_7) V(Node1_9_8) V(Node1_9_9) V(Node1_9_10) V(Node1_9_11) V(Node1_9_12) V(Node1_9_13) V(Node1_9_14) V(Node1_9_15) V(Node1_9_16) V(Node1_9_17) V(Node1_9_18) V(Node1_9_19) V(Node1_9_20) V(Node1_9_21) V(Node1_9_22) V(Node1_9_23) V(Node1_9_24) V(Node1_9_25) V(Node1_9_26) V(Node1_9_27) V(Node1_9_28) V(Node1_9_29) V(Node1_9_30) V(Node1_9_31) V(Node1_10_0) V(Node1_10_1) V(Node1_10_2) V(Node1_10_3) V(Node1_10_4) V(Node1_10_5) V(Node1_10_6) V(Node1_10_7) V(Node1_10_8) V(Node1_10_9) V(Node1_10_10) V(Node1_10_11) V(Node1_10_12) V(Node1_10_13) V(Node1_10_14) V(Node1_10_15) V(Node1_10_16) V(Node1_10_17) V(Node1_10_18) V(Node1_10_19) V(Node1_10_20) V(Node1_10_21) V(Node1_10_22) V(Node1_10_23) V(Node1_10_24) V(Node1_10_25) V(Node1_10_26) V(Node1_10_27) V(Node1_10_28) V(Node1_10_29) V(Node1_10_30) V(Node1_10_31) V(Node1_11_0) V(Node1_11_1) V(Node1_11_2) V(Node1_11_3) V(Node1_11_4) V(Node1_11_5) V(Node1_11_6) V(Node1_11_7) V(Node1_11_8) V(Node1_11_9) V(Node1_11_10) V(Node1_11_11) V(Node1_11_12) V(Node1_11_13) V(Node1_11_14) V(Node1_11_15) V(Node1_11_16) V(Node1_11_17) V(Node1_11_18) V(Node1_11_19) V(Node1_11_20) V(Node1_11_21) V(Node1_11_22) V(Node1_11_23) V(Node1_11_24) V(Node1_11_25) V(Node1_11_26) V(Node1_11_27) V(Node1_11_28) V(Node1_11_29) V(Node1_11_30) V(Node1_11_31) V(Node1_12_0) V(Node1_12_1) V(Node1_12_2) V(Node1_12_3) V(Node1_12_4) V(Node1_12_5) V(Node1_12_6) V(Node1_12_7) V(Node1_12_8) V(Node1_12_9) V(Node1_12_10) V(Node1_12_11) V(Node1_12_12) V(Node1_12_13) V(Node1_12_14) V(Node1_12_15) V(Node1_12_16) V(Node1_12_17) V(Node1_12_18) V(Node1_12_19) V(Node1_12_20) V(Node1_12_21) V(Node1_12_22) V(Node1_12_23) V(Node1_12_24) V(Node1_12_25) V(Node1_12_26) V(Node1_12_27) V(Node1_12_28) V(Node1_12_29) V(Node1_12_30) V(Node1_12_31) V(Node1_13_0) V(Node1_13_1) V(Node1_13_2) V(Node1_13_3) V(Node1_13_4) V(Node1_13_5) V(Node1_13_6) V(Node1_13_7) V(Node1_13_8) V(Node1_13_9) V(Node1_13_10) V(Node1_13_11) V(Node1_13_12) V(Node1_13_13) V(Node1_13_14) V(Node1_13_15) V(Node1_13_16) V(Node1_13_17) V(Node1_13_18) V(Node1_13_19) V(Node1_13_20) V(Node1_13_21) V(Node1_13_22) V(Node1_13_23) V(Node1_13_24) V(Node1_13_25) V(Node1_13_26) V(Node1_13_27) V(Node1_13_28) V(Node1_13_29) V(Node1_13_30) V(Node1_13_31) V(Node1_14_0) V(Node1_14_1) V(Node1_14_2) V(Node1_14_3) V(Node1_14_4) V(Node1_14_5) V(Node1_14_6) V(Node1_14_7) V(Node1_14_8) V(Node1_14_9) V(Node1_14_10) V(Node1_14_11) V(Node1_14_12) V(Node1_14_13) V(Node1_14_14) V(Node1_14_15) V(Node1_14_16) V(Node1_14_17) V(Node1_14_18) V(Node1_14_19) V(Node1_14_20) V(Node1_14_21) V(Node1_14_22) V(Node1_14_23) V(Node1_14_24) V(Node1_14_25) V(Node1_14_26) V(Node1_14_27) V(Node1_14_28) V(Node1_14_29) V(Node1_14_30) V(Node1_14_31) V(Node1_15_0) V(Node1_15_1) V(Node1_15_2) V(Node1_15_3) V(Node1_15_4) V(Node1_15_5) V(Node1_15_6) V(Node1_15_7) V(Node1_15_8) V(Node1_15_9) V(Node1_15_10) V(Node1_15_11) V(Node1_15_12) V(Node1_15_13) V(Node1_15_14) V(Node1_15_15) V(Node1_15_16) V(Node1_15_17) V(Node1_15_18) V(Node1_15_19) V(Node1_15_20) V(Node1_15_21) V(Node1_15_22) V(Node1_15_23) V(Node1_15_24) V(Node1_15_25) V(Node1_15_26) V(Node1_15_27) V(Node1_15_28) V(Node1_15_29) V(Node1_15_30) V(Node1_15_31) V(Node1_16_0) V(Node1_16_1) V(Node1_16_2) V(Node1_16_3) V(Node1_16_4) V(Node1_16_5) V(Node1_16_6) V(Node1_16_7) V(Node1_16_8) V(Node1_16_9) V(Node1_16_10) V(Node1_16_11) V(Node1_16_12) V(Node1_16_13) V(Node1_16_14) V(Node1_16_15) V(Node1_16_16) V(Node1_16_17) V(Node1_16_18) V(Node1_16_19) V(Node1_16_20) V(Node1_16_21) V(Node1_16_22) V(Node1_16_23) V(Node1_16_24) V(Node1_16_25) V(Node1_16_26) V(Node1_16_27) V(Node1_16_28) V(Node1_16_29) V(Node1_16_30) V(Node1_16_31) V(Node1_17_0) V(Node1_17_1) V(Node1_17_2) V(Node1_17_3) V(Node1_17_4) V(Node1_17_5) V(Node1_17_6) V(Node1_17_7) V(Node1_17_8) V(Node1_17_9) V(Node1_17_10) V(Node1_17_11) V(Node1_17_12) V(Node1_17_13) V(Node1_17_14) V(Node1_17_15) V(Node1_17_16) V(Node1_17_17) V(Node1_17_18) V(Node1_17_19) V(Node1_17_20) V(Node1_17_21) V(Node1_17_22) V(Node1_17_23) V(Node1_17_24) V(Node1_17_25) V(Node1_17_26) V(Node1_17_27) V(Node1_17_28) V(Node1_17_29) V(Node1_17_30) V(Node1_17_31) V(Node1_18_0) V(Node1_18_1) V(Node1_18_2) V(Node1_18_3) V(Node1_18_4) V(Node1_18_5) V(Node1_18_6) V(Node1_18_7) V(Node1_18_8) V(Node1_18_9) V(Node1_18_10) V(Node1_18_11) V(Node1_18_12) V(Node1_18_13) V(Node1_18_14) V(Node1_18_15) V(Node1_18_16) V(Node1_18_17) V(Node1_18_18) V(Node1_18_19) V(Node1_18_20) V(Node1_18_21) V(Node1_18_22) V(Node1_18_23) V(Node1_18_24) V(Node1_18_25) V(Node1_18_26) V(Node1_18_27) V(Node1_18_28) V(Node1_18_29) V(Node1_18_30) V(Node1_18_31) V(Node1_19_0) V(Node1_19_1) V(Node1_19_2) V(Node1_19_3) V(Node1_19_4) V(Node1_19_5) V(Node1_19_6) V(Node1_19_7) V(Node1_19_8) V(Node1_19_9) V(Node1_19_10) V(Node1_19_11) V(Node1_19_12) V(Node1_19_13) V(Node1_19_14) V(Node1_19_15) V(Node1_19_16) V(Node1_19_17) V(Node1_19_18) V(Node1_19_19) V(Node1_19_20) V(Node1_19_21) V(Node1_19_22) V(Node1_19_23) V(Node1_19_24) V(Node1_19_25) V(Node1_19_26) V(Node1_19_27) V(Node1_19_28) V(Node1_19_29) V(Node1_19_30) V(Node1_19_31) V(Node1_20_0) V(Node1_20_1) V(Node1_20_2) V(Node1_20_3) V(Node1_20_4) V(Node1_20_5) V(Node1_20_6) V(Node1_20_7) V(Node1_20_8) V(Node1_20_9) V(Node1_20_10) V(Node1_20_11) V(Node1_20_12) V(Node1_20_13) V(Node1_20_14) V(Node1_20_15) V(Node1_20_16) V(Node1_20_17) V(Node1_20_18) V(Node1_20_19) V(Node1_20_20) V(Node1_20_21) V(Node1_20_22) V(Node1_20_23) V(Node1_20_24) V(Node1_20_25) V(Node1_20_26) V(Node1_20_27) V(Node1_20_28) V(Node1_20_29) V(Node1_20_30) V(Node1_20_31) V(Node1_21_0) V(Node1_21_1) V(Node1_21_2) V(Node1_21_3) V(Node1_21_4) V(Node1_21_5) V(Node1_21_6) V(Node1_21_7) V(Node1_21_8) V(Node1_21_9) V(Node1_21_10) V(Node1_21_11) V(Node1_21_12) V(Node1_21_13) V(Node1_21_14) V(Node1_21_15) V(Node1_21_16) V(Node1_21_17) V(Node1_21_18) V(Node1_21_19) V(Node1_21_20) V(Node1_21_21) V(Node1_21_22) V(Node1_21_23) V(Node1_21_24) V(Node1_21_25) V(Node1_21_26) V(Node1_21_27) V(Node1_21_28) V(Node1_21_29) V(Node1_21_30) V(Node1_21_31) V(Node1_22_0) V(Node1_22_1) V(Node1_22_2) V(Node1_22_3) V(Node1_22_4) V(Node1_22_5) V(Node1_22_6) V(Node1_22_7) V(Node1_22_8) V(Node1_22_9) V(Node1_22_10) V(Node1_22_11) V(Node1_22_12) V(Node1_22_13) V(Node1_22_14) V(Node1_22_15) V(Node1_22_16) V(Node1_22_17) V(Node1_22_18) V(Node1_22_19) V(Node1_22_20) V(Node1_22_21) V(Node1_22_22) V(Node1_22_23) V(Node1_22_24) V(Node1_22_25) V(Node1_22_26) V(Node1_22_27) V(Node1_22_28) V(Node1_22_29) V(Node1_22_30) V(Node1_22_31) V(Node1_23_0) V(Node1_23_1) V(Node1_23_2) V(Node1_23_3) V(Node1_23_4) V(Node1_23_5) V(Node1_23_6) V(Node1_23_7) V(Node1_23_8) V(Node1_23_9) V(Node1_23_10) V(Node1_23_11) V(Node1_23_12) V(Node1_23_13) V(Node1_23_14) V(Node1_23_15) V(Node1_23_16) V(Node1_23_17) V(Node1_23_18) V(Node1_23_19) V(Node1_23_20) V(Node1_23_21) V(Node1_23_22) V(Node1_23_23) V(Node1_23_24) V(Node1_23_25) V(Node1_23_26) V(Node1_23_27) V(Node1_23_28) V(Node1_23_29) V(Node1_23_30) V(Node1_23_31) V(Node1_24_0) V(Node1_24_1) V(Node1_24_2) V(Node1_24_3) V(Node1_24_4) V(Node1_24_5) V(Node1_24_6) V(Node1_24_7) V(Node1_24_8) V(Node1_24_9) V(Node1_24_10) V(Node1_24_11) V(Node1_24_12) V(Node1_24_13) V(Node1_24_14) V(Node1_24_15) V(Node1_24_16) V(Node1_24_17) V(Node1_24_18) V(Node1_24_19) V(Node1_24_20) V(Node1_24_21) V(Node1_24_22) V(Node1_24_23) V(Node1_24_24) V(Node1_24_25) V(Node1_24_26) V(Node1_24_27) V(Node1_24_28) V(Node1_24_29) V(Node1_24_30) V(Node1_24_31) V(Node1_25_0) V(Node1_25_1) V(Node1_25_2) V(Node1_25_3) V(Node1_25_4) V(Node1_25_5) V(Node1_25_6) V(Node1_25_7) V(Node1_25_8) V(Node1_25_9) V(Node1_25_10) V(Node1_25_11) V(Node1_25_12) V(Node1_25_13) V(Node1_25_14) V(Node1_25_15) V(Node1_25_16) V(Node1_25_17) V(Node1_25_18) V(Node1_25_19) V(Node1_25_20) V(Node1_25_21) V(Node1_25_22) V(Node1_25_23) V(Node1_25_24) V(Node1_25_25) V(Node1_25_26) V(Node1_25_27) V(Node1_25_28) V(Node1_25_29) V(Node1_25_30) V(Node1_25_31) V(Node1_26_0) V(Node1_26_1) V(Node1_26_2) V(Node1_26_3) V(Node1_26_4) V(Node1_26_5) V(Node1_26_6) V(Node1_26_7) V(Node1_26_8) V(Node1_26_9) V(Node1_26_10) V(Node1_26_11) V(Node1_26_12) V(Node1_26_13) V(Node1_26_14) V(Node1_26_15) V(Node1_26_16) V(Node1_26_17) V(Node1_26_18) V(Node1_26_19) V(Node1_26_20) V(Node1_26_21) V(Node1_26_22) V(Node1_26_23) V(Node1_26_24) V(Node1_26_25) V(Node1_26_26) V(Node1_26_27) V(Node1_26_28) V(Node1_26_29) V(Node1_26_30) V(Node1_26_31) V(Node1_27_0) V(Node1_27_1) V(Node1_27_2) V(Node1_27_3) V(Node1_27_4) V(Node1_27_5) V(Node1_27_6) V(Node1_27_7) V(Node1_27_8) V(Node1_27_9) V(Node1_27_10) V(Node1_27_11) V(Node1_27_12) V(Node1_27_13) V(Node1_27_14) V(Node1_27_15) V(Node1_27_16) V(Node1_27_17) V(Node1_27_18) V(Node1_27_19) V(Node1_27_20) V(Node1_27_21) V(Node1_27_22) V(Node1_27_23) V(Node1_27_24) V(Node1_27_25) V(Node1_27_26) V(Node1_27_27) V(Node1_27_28) V(Node1_27_29) V(Node1_27_30) V(Node1_27_31) V(Node1_28_0) V(Node1_28_1) V(Node1_28_2) V(Node1_28_3) V(Node1_28_4) V(Node1_28_5) V(Node1_28_6) V(Node1_28_7) V(Node1_28_8) V(Node1_28_9) V(Node1_28_10) V(Node1_28_11) V(Node1_28_12) V(Node1_28_13) V(Node1_28_14) V(Node1_28_15) V(Node1_28_16) V(Node1_28_17) V(Node1_28_18) V(Node1_28_19) V(Node1_28_20) V(Node1_28_21) V(Node1_28_22) V(Node1_28_23) V(Node1_28_24) V(Node1_28_25) V(Node1_28_26) V(Node1_28_27) V(Node1_28_28) V(Node1_28_29) V(Node1_28_30) V(Node1_28_31) V(Node1_29_0) V(Node1_29_1) V(Node1_29_2) V(Node1_29_3) V(Node1_29_4) V(Node1_29_5) V(Node1_29_6) V(Node1_29_7) V(Node1_29_8) V(Node1_29_9) V(Node1_29_10) V(Node1_29_11) V(Node1_29_12) V(Node1_29_13) V(Node1_29_14) V(Node1_29_15) V(Node1_29_16) V(Node1_29_17) V(Node1_29_18) V(Node1_29_19) V(Node1_29_20) V(Node1_29_21) V(Node1_29_22) V(Node1_29_23) V(Node1_29_24) V(Node1_29_25) V(Node1_29_26) V(Node1_29_27) V(Node1_29_28) V(Node1_29_29) V(Node1_29_30) V(Node1_29_31) V(Node1_30_0) V(Node1_30_1) V(Node1_30_2) V(Node1_30_3) V(Node1_30_4) V(Node1_30_5) V(Node1_30_6) V(Node1_30_7) V(Node1_30_8) V(Node1_30_9) V(Node1_30_10) V(Node1_30_11) V(Node1_30_12) V(Node1_30_13) V(Node1_30_14) V(Node1_30_15) V(Node1_30_16) V(Node1_30_17) V(Node1_30_18) V(Node1_30_19) V(Node1_30_20) V(Node1_30_21) V(Node1_30_22) V(Node1_30_23) V(Node1_30_24) V(Node1_30_25) V(Node1_30_26) V(Node1_30_27) V(Node1_30_28) V(Node1_30_29) V(Node1_30_30) V(Node1_30_31) V(Node1_31_0) V(Node1_31_1) V(Node1_31_2) V(Node1_31_3) V(Node1_31_4) V(Node1_31_5) V(Node1_31_6) V(Node1_31_7) V(Node1_31_8) V(Node1_31_9) V(Node1_31_10) V(Node1_31_11) V(Node1_31_12) V(Node1_31_13) V(Node1_31_14) V(Node1_31_15) V(Node1_31_16) V(Node1_31_17) V(Node1_31_18) V(Node1_31_19) V(Node1_31_20) V(Node1_31_21) V(Node1_31_22) V(Node1_31_23) V(Node1_31_24) V(Node1_31_25) V(Node1_31_26) V(Node1_31_27) V(Node1_31_28) V(Node1_31_29) V(Node1_31_30) V(Node1_31_31) V(Node2_0_0) V(Node2_0_1) V(Node2_0_2) V(Node2_0_3) V(Node2_0_4) V(Node2_0_5) V(Node2_0_6) V(Node2_0_7) V(Node2_0_8) V(Node2_0_9) V(Node2_0_10) V(Node2_0_11) V(Node2_0_12) V(Node2_0_13) V(Node2_0_14) V(Node2_0_15) V(Node2_0_16) V(Node2_0_17) V(Node2_0_18) V(Node2_0_19) V(Node2_0_20) V(Node2_0_21) V(Node2_0_22) V(Node2_0_23) V(Node2_0_24) V(Node2_0_25) V(Node2_0_26) V(Node2_0_27) V(Node2_0_28) V(Node2_0_29) V(Node2_0_30) V(Node2_0_31) V(Node2_1_0) V(Node2_1_1) V(Node2_1_2) V(Node2_1_3) V(Node2_1_4) V(Node2_1_5) V(Node2_1_6) V(Node2_1_7) V(Node2_1_8) V(Node2_1_9) V(Node2_1_10) V(Node2_1_11) V(Node2_1_12) V(Node2_1_13) V(Node2_1_14) V(Node2_1_15) V(Node2_1_16) V(Node2_1_17) V(Node2_1_18) V(Node2_1_19) V(Node2_1_20) V(Node2_1_21) V(Node2_1_22) V(Node2_1_23) V(Node2_1_24) V(Node2_1_25) V(Node2_1_26) V(Node2_1_27) V(Node2_1_28) V(Node2_1_29) V(Node2_1_30) V(Node2_1_31) V(Node2_2_0) V(Node2_2_1) V(Node2_2_2) V(Node2_2_3) V(Node2_2_4) V(Node2_2_5) V(Node2_2_6) V(Node2_2_7) V(Node2_2_8) V(Node2_2_9) V(Node2_2_10) V(Node2_2_11) V(Node2_2_12) V(Node2_2_13) V(Node2_2_14) V(Node2_2_15) V(Node2_2_16) V(Node2_2_17) V(Node2_2_18) V(Node2_2_19) V(Node2_2_20) V(Node2_2_21) V(Node2_2_22) V(Node2_2_23) V(Node2_2_24) V(Node2_2_25) V(Node2_2_26) V(Node2_2_27) V(Node2_2_28) V(Node2_2_29) V(Node2_2_30) V(Node2_2_31) V(Node2_3_0) V(Node2_3_1) V(Node2_3_2) V(Node2_3_3) V(Node2_3_4) V(Node2_3_5) V(Node2_3_6) V(Node2_3_7) V(Node2_3_8) V(Node2_3_9) V(Node2_3_10) V(Node2_3_11) V(Node2_3_12) V(Node2_3_13) V(Node2_3_14) V(Node2_3_15) V(Node2_3_16) V(Node2_3_17) V(Node2_3_18) V(Node2_3_19) V(Node2_3_20) V(Node2_3_21) V(Node2_3_22) V(Node2_3_23) V(Node2_3_24) V(Node2_3_25) V(Node2_3_26) V(Node2_3_27) V(Node2_3_28) V(Node2_3_29) V(Node2_3_30) V(Node2_3_31) V(Node2_4_0) V(Node2_4_1) V(Node2_4_2) V(Node2_4_3) V(Node2_4_4) V(Node2_4_5) V(Node2_4_6) V(Node2_4_7) V(Node2_4_8) V(Node2_4_9) V(Node2_4_10) V(Node2_4_11) V(Node2_4_12) V(Node2_4_13) V(Node2_4_14) V(Node2_4_15) V(Node2_4_16) V(Node2_4_17) V(Node2_4_18) V(Node2_4_19) V(Node2_4_20) V(Node2_4_21) V(Node2_4_22) V(Node2_4_23) V(Node2_4_24) V(Node2_4_25) V(Node2_4_26) V(Node2_4_27) V(Node2_4_28) V(Node2_4_29) V(Node2_4_30) V(Node2_4_31) V(Node2_5_0) V(Node2_5_1) V(Node2_5_2) V(Node2_5_3) V(Node2_5_4) V(Node2_5_5) V(Node2_5_6) V(Node2_5_7) V(Node2_5_8) V(Node2_5_9) V(Node2_5_10) V(Node2_5_11) V(Node2_5_12) V(Node2_5_13) V(Node2_5_14) V(Node2_5_15) V(Node2_5_16) V(Node2_5_17) V(Node2_5_18) V(Node2_5_19) V(Node2_5_20) V(Node2_5_21) V(Node2_5_22) V(Node2_5_23) V(Node2_5_24) V(Node2_5_25) V(Node2_5_26) V(Node2_5_27) V(Node2_5_28) V(Node2_5_29) V(Node2_5_30) V(Node2_5_31) V(Node2_6_0) V(Node2_6_1) V(Node2_6_2) V(Node2_6_3) V(Node2_6_4) V(Node2_6_5) V(Node2_6_6) V(Node2_6_7) V(Node2_6_8) V(Node2_6_9) V(Node2_6_10) V(Node2_6_11) V(Node2_6_12) V(Node2_6_13) V(Node2_6_14) V(Node2_6_15) V(Node2_6_16) V(Node2_6_17) V(Node2_6_18) V(Node2_6_19) V(Node2_6_20) V(Node2_6_21) V(Node2_6_22) V(Node2_6_23) V(Node2_6_24) V(Node2_6_25) V(Node2_6_26) V(Node2_6_27) V(Node2_6_28) V(Node2_6_29) V(Node2_6_30) V(Node2_6_31) V(Node2_7_0) V(Node2_7_1) V(Node2_7_2) V(Node2_7_3) V(Node2_7_4) V(Node2_7_5) V(Node2_7_6) V(Node2_7_7) V(Node2_7_8) V(Node2_7_9) V(Node2_7_10) V(Node2_7_11) V(Node2_7_12) V(Node2_7_13) V(Node2_7_14) V(Node2_7_15) V(Node2_7_16) V(Node2_7_17) V(Node2_7_18) V(Node2_7_19) V(Node2_7_20) V(Node2_7_21) V(Node2_7_22) V(Node2_7_23) V(Node2_7_24) V(Node2_7_25) V(Node2_7_26) V(Node2_7_27) V(Node2_7_28) V(Node2_7_29) V(Node2_7_30) V(Node2_7_31) V(Node2_8_0) V(Node2_8_1) V(Node2_8_2) V(Node2_8_3) V(Node2_8_4) V(Node2_8_5) V(Node2_8_6) V(Node2_8_7) V(Node2_8_8) V(Node2_8_9) V(Node2_8_10) V(Node2_8_11) V(Node2_8_12) V(Node2_8_13) V(Node2_8_14) V(Node2_8_15) V(Node2_8_16) V(Node2_8_17) V(Node2_8_18) V(Node2_8_19) V(Node2_8_20) V(Node2_8_21) V(Node2_8_22) V(Node2_8_23) V(Node2_8_24) V(Node2_8_25) V(Node2_8_26) V(Node2_8_27) V(Node2_8_28) V(Node2_8_29) V(Node2_8_30) V(Node2_8_31) V(Node2_9_0) V(Node2_9_1) V(Node2_9_2) V(Node2_9_3) V(Node2_9_4) V(Node2_9_5) V(Node2_9_6) V(Node2_9_7) V(Node2_9_8) V(Node2_9_9) V(Node2_9_10) V(Node2_9_11) V(Node2_9_12) V(Node2_9_13) V(Node2_9_14) V(Node2_9_15) V(Node2_9_16) V(Node2_9_17) V(Node2_9_18) V(Node2_9_19) V(Node2_9_20) V(Node2_9_21) V(Node2_9_22) V(Node2_9_23) V(Node2_9_24) V(Node2_9_25) V(Node2_9_26) V(Node2_9_27) V(Node2_9_28) V(Node2_9_29) V(Node2_9_30) V(Node2_9_31) V(Node2_10_0) V(Node2_10_1) V(Node2_10_2) V(Node2_10_3) V(Node2_10_4) V(Node2_10_5) V(Node2_10_6) V(Node2_10_7) V(Node2_10_8) V(Node2_10_9) V(Node2_10_10) V(Node2_10_11) V(Node2_10_12) V(Node2_10_13) V(Node2_10_14) V(Node2_10_15) V(Node2_10_16) V(Node2_10_17) V(Node2_10_18) V(Node2_10_19) V(Node2_10_20) V(Node2_10_21) V(Node2_10_22) V(Node2_10_23) V(Node2_10_24) V(Node2_10_25) V(Node2_10_26) V(Node2_10_27) V(Node2_10_28) V(Node2_10_29) V(Node2_10_30) V(Node2_10_31) V(Node2_11_0) V(Node2_11_1) V(Node2_11_2) V(Node2_11_3) V(Node2_11_4) V(Node2_11_5) V(Node2_11_6) V(Node2_11_7) V(Node2_11_8) V(Node2_11_9) V(Node2_11_10) V(Node2_11_11) V(Node2_11_12) V(Node2_11_13) V(Node2_11_14) V(Node2_11_15) V(Node2_11_16) V(Node2_11_17) V(Node2_11_18) V(Node2_11_19) V(Node2_11_20) V(Node2_11_21) V(Node2_11_22) V(Node2_11_23) V(Node2_11_24) V(Node2_11_25) V(Node2_11_26) V(Node2_11_27) V(Node2_11_28) V(Node2_11_29) V(Node2_11_30) V(Node2_11_31) V(Node2_12_0) V(Node2_12_1) V(Node2_12_2) V(Node2_12_3) V(Node2_12_4) V(Node2_12_5) V(Node2_12_6) V(Node2_12_7) V(Node2_12_8) V(Node2_12_9) V(Node2_12_10) V(Node2_12_11) V(Node2_12_12) V(Node2_12_13) V(Node2_12_14) V(Node2_12_15) V(Node2_12_16) V(Node2_12_17) V(Node2_12_18) V(Node2_12_19) V(Node2_12_20) V(Node2_12_21) V(Node2_12_22) V(Node2_12_23) V(Node2_12_24) V(Node2_12_25) V(Node2_12_26) V(Node2_12_27) V(Node2_12_28) V(Node2_12_29) V(Node2_12_30) V(Node2_12_31) V(Node2_13_0) V(Node2_13_1) V(Node2_13_2) V(Node2_13_3) V(Node2_13_4) V(Node2_13_5) V(Node2_13_6) V(Node2_13_7) V(Node2_13_8) V(Node2_13_9) V(Node2_13_10) V(Node2_13_11) V(Node2_13_12) V(Node2_13_13) V(Node2_13_14) V(Node2_13_15) V(Node2_13_16) V(Node2_13_17) V(Node2_13_18) V(Node2_13_19) V(Node2_13_20) V(Node2_13_21) V(Node2_13_22) V(Node2_13_23) V(Node2_13_24) V(Node2_13_25) V(Node2_13_26) V(Node2_13_27) V(Node2_13_28) V(Node2_13_29) V(Node2_13_30) V(Node2_13_31) V(Node2_14_0) V(Node2_14_1) V(Node2_14_2) V(Node2_14_3) V(Node2_14_4) V(Node2_14_5) V(Node2_14_6) V(Node2_14_7) V(Node2_14_8) V(Node2_14_9) V(Node2_14_10) V(Node2_14_11) V(Node2_14_12) V(Node2_14_13) V(Node2_14_14) V(Node2_14_15) V(Node2_14_16) V(Node2_14_17) V(Node2_14_18) V(Node2_14_19) V(Node2_14_20) V(Node2_14_21) V(Node2_14_22) V(Node2_14_23) V(Node2_14_24) V(Node2_14_25) V(Node2_14_26) V(Node2_14_27) V(Node2_14_28) V(Node2_14_29) V(Node2_14_30) V(Node2_14_31) V(Node2_15_0) V(Node2_15_1) V(Node2_15_2) V(Node2_15_3) V(Node2_15_4) V(Node2_15_5) V(Node2_15_6) V(Node2_15_7) V(Node2_15_8) V(Node2_15_9) V(Node2_15_10) V(Node2_15_11) V(Node2_15_12) V(Node2_15_13) V(Node2_15_14) V(Node2_15_15) V(Node2_15_16) V(Node2_15_17) V(Node2_15_18) V(Node2_15_19) V(Node2_15_20) V(Node2_15_21) V(Node2_15_22) V(Node2_15_23) V(Node2_15_24) V(Node2_15_25) V(Node2_15_26) V(Node2_15_27) V(Node2_15_28) V(Node2_15_29) V(Node2_15_30) V(Node2_15_31) V(Node2_16_0) V(Node2_16_1) V(Node2_16_2) V(Node2_16_3) V(Node2_16_4) V(Node2_16_5) V(Node2_16_6) V(Node2_16_7) V(Node2_16_8) V(Node2_16_9) V(Node2_16_10) V(Node2_16_11) V(Node2_16_12) V(Node2_16_13) V(Node2_16_14) V(Node2_16_15) V(Node2_16_16) V(Node2_16_17) V(Node2_16_18) V(Node2_16_19) V(Node2_16_20) V(Node2_16_21) V(Node2_16_22) V(Node2_16_23) V(Node2_16_24) V(Node2_16_25) V(Node2_16_26) V(Node2_16_27) V(Node2_16_28) V(Node2_16_29) V(Node2_16_30) V(Node2_16_31) V(Node2_17_0) V(Node2_17_1) V(Node2_17_2) V(Node2_17_3) V(Node2_17_4) V(Node2_17_5) V(Node2_17_6) V(Node2_17_7) V(Node2_17_8) V(Node2_17_9) V(Node2_17_10) V(Node2_17_11) V(Node2_17_12) V(Node2_17_13) V(Node2_17_14) V(Node2_17_15) V(Node2_17_16) V(Node2_17_17) V(Node2_17_18) V(Node2_17_19) V(Node2_17_20) V(Node2_17_21) V(Node2_17_22) V(Node2_17_23) V(Node2_17_24) V(Node2_17_25) V(Node2_17_26) V(Node2_17_27) V(Node2_17_28) V(Node2_17_29) V(Node2_17_30) V(Node2_17_31) V(Node2_18_0) V(Node2_18_1) V(Node2_18_2) V(Node2_18_3) V(Node2_18_4) V(Node2_18_5) V(Node2_18_6) V(Node2_18_7) V(Node2_18_8) V(Node2_18_9) V(Node2_18_10) V(Node2_18_11) V(Node2_18_12) V(Node2_18_13) V(Node2_18_14) V(Node2_18_15) V(Node2_18_16) V(Node2_18_17) V(Node2_18_18) V(Node2_18_19) V(Node2_18_20) V(Node2_18_21) V(Node2_18_22) V(Node2_18_23) V(Node2_18_24) V(Node2_18_25) V(Node2_18_26) V(Node2_18_27) V(Node2_18_28) V(Node2_18_29) V(Node2_18_30) V(Node2_18_31) V(Node2_19_0) V(Node2_19_1) V(Node2_19_2) V(Node2_19_3) V(Node2_19_4) V(Node2_19_5) V(Node2_19_6) V(Node2_19_7) V(Node2_19_8) V(Node2_19_9) V(Node2_19_10) V(Node2_19_11) V(Node2_19_12) V(Node2_19_13) V(Node2_19_14) V(Node2_19_15) V(Node2_19_16) V(Node2_19_17) V(Node2_19_18) V(Node2_19_19) V(Node2_19_20) V(Node2_19_21) V(Node2_19_22) V(Node2_19_23) V(Node2_19_24) V(Node2_19_25) V(Node2_19_26) V(Node2_19_27) V(Node2_19_28) V(Node2_19_29) V(Node2_19_30) V(Node2_19_31) V(Node2_20_0) V(Node2_20_1) V(Node2_20_2) V(Node2_20_3) V(Node2_20_4) V(Node2_20_5) V(Node2_20_6) V(Node2_20_7) V(Node2_20_8) V(Node2_20_9) V(Node2_20_10) V(Node2_20_11) V(Node2_20_12) V(Node2_20_13) V(Node2_20_14) V(Node2_20_15) V(Node2_20_16) V(Node2_20_17) V(Node2_20_18) V(Node2_20_19) V(Node2_20_20) V(Node2_20_21) V(Node2_20_22) V(Node2_20_23) V(Node2_20_24) V(Node2_20_25) V(Node2_20_26) V(Node2_20_27) V(Node2_20_28) V(Node2_20_29) V(Node2_20_30) V(Node2_20_31) V(Node2_21_0) V(Node2_21_1) V(Node2_21_2) V(Node2_21_3) V(Node2_21_4) V(Node2_21_5) V(Node2_21_6) V(Node2_21_7) V(Node2_21_8) V(Node2_21_9) V(Node2_21_10) V(Node2_21_11) V(Node2_21_12) V(Node2_21_13) V(Node2_21_14) V(Node2_21_15) V(Node2_21_16) V(Node2_21_17) V(Node2_21_18) V(Node2_21_19) V(Node2_21_20) V(Node2_21_21) V(Node2_21_22) V(Node2_21_23) V(Node2_21_24) V(Node2_21_25) V(Node2_21_26) V(Node2_21_27) V(Node2_21_28) V(Node2_21_29) V(Node2_21_30) V(Node2_21_31) V(Node2_22_0) V(Node2_22_1) V(Node2_22_2) V(Node2_22_3) V(Node2_22_4) V(Node2_22_5) V(Node2_22_6) V(Node2_22_7) V(Node2_22_8) V(Node2_22_9) V(Node2_22_10) V(Node2_22_11) V(Node2_22_12) V(Node2_22_13) V(Node2_22_14) V(Node2_22_15) V(Node2_22_16) V(Node2_22_17) V(Node2_22_18) V(Node2_22_19) V(Node2_22_20) V(Node2_22_21) V(Node2_22_22) V(Node2_22_23) V(Node2_22_24) V(Node2_22_25) V(Node2_22_26) V(Node2_22_27) V(Node2_22_28) V(Node2_22_29) V(Node2_22_30) V(Node2_22_31) V(Node2_23_0) V(Node2_23_1) V(Node2_23_2) V(Node2_23_3) V(Node2_23_4) V(Node2_23_5) V(Node2_23_6) V(Node2_23_7) V(Node2_23_8) V(Node2_23_9) V(Node2_23_10) V(Node2_23_11) V(Node2_23_12) V(Node2_23_13) V(Node2_23_14) V(Node2_23_15) V(Node2_23_16) V(Node2_23_17) V(Node2_23_18) V(Node2_23_19) V(Node2_23_20) V(Node2_23_21) V(Node2_23_22) V(Node2_23_23) V(Node2_23_24) V(Node2_23_25) V(Node2_23_26) V(Node2_23_27) V(Node2_23_28) V(Node2_23_29) V(Node2_23_30) V(Node2_23_31) V(Node2_24_0) V(Node2_24_1) V(Node2_24_2) V(Node2_24_3) V(Node2_24_4) V(Node2_24_5) V(Node2_24_6) V(Node2_24_7) V(Node2_24_8) V(Node2_24_9) V(Node2_24_10) V(Node2_24_11) V(Node2_24_12) V(Node2_24_13) V(Node2_24_14) V(Node2_24_15) V(Node2_24_16) V(Node2_24_17) V(Node2_24_18) V(Node2_24_19) V(Node2_24_20) V(Node2_24_21) V(Node2_24_22) V(Node2_24_23) V(Node2_24_24) V(Node2_24_25) V(Node2_24_26) V(Node2_24_27) V(Node2_24_28) V(Node2_24_29) V(Node2_24_30) V(Node2_24_31) V(Node2_25_0) V(Node2_25_1) V(Node2_25_2) V(Node2_25_3) V(Node2_25_4) V(Node2_25_5) V(Node2_25_6) V(Node2_25_7) V(Node2_25_8) V(Node2_25_9) V(Node2_25_10) V(Node2_25_11) V(Node2_25_12) V(Node2_25_13) V(Node2_25_14) V(Node2_25_15) V(Node2_25_16) V(Node2_25_17) V(Node2_25_18) V(Node2_25_19) V(Node2_25_20) V(Node2_25_21) V(Node2_25_22) V(Node2_25_23) V(Node2_25_24) V(Node2_25_25) V(Node2_25_26) V(Node2_25_27) V(Node2_25_28) V(Node2_25_29) V(Node2_25_30) V(Node2_25_31) V(Node2_26_0) V(Node2_26_1) V(Node2_26_2) V(Node2_26_3) V(Node2_26_4) V(Node2_26_5) V(Node2_26_6) V(Node2_26_7) V(Node2_26_8) V(Node2_26_9) V(Node2_26_10) V(Node2_26_11) V(Node2_26_12) V(Node2_26_13) V(Node2_26_14) V(Node2_26_15) V(Node2_26_16) V(Node2_26_17) V(Node2_26_18) V(Node2_26_19) V(Node2_26_20) V(Node2_26_21) V(Node2_26_22) V(Node2_26_23) V(Node2_26_24) V(Node2_26_25) V(Node2_26_26) V(Node2_26_27) V(Node2_26_28) V(Node2_26_29) V(Node2_26_30) V(Node2_26_31) V(Node2_27_0) V(Node2_27_1) V(Node2_27_2) V(Node2_27_3) V(Node2_27_4) V(Node2_27_5) V(Node2_27_6) V(Node2_27_7) V(Node2_27_8) V(Node2_27_9) V(Node2_27_10) V(Node2_27_11) V(Node2_27_12) V(Node2_27_13) V(Node2_27_14) V(Node2_27_15) V(Node2_27_16) V(Node2_27_17) V(Node2_27_18) V(Node2_27_19) V(Node2_27_20) V(Node2_27_21) V(Node2_27_22) V(Node2_27_23) V(Node2_27_24) V(Node2_27_25) V(Node2_27_26) V(Node2_27_27) V(Node2_27_28) V(Node2_27_29) V(Node2_27_30) V(Node2_27_31) V(Node2_28_0) V(Node2_28_1) V(Node2_28_2) V(Node2_28_3) V(Node2_28_4) V(Node2_28_5) V(Node2_28_6) V(Node2_28_7) V(Node2_28_8) V(Node2_28_9) V(Node2_28_10) V(Node2_28_11) V(Node2_28_12) V(Node2_28_13) V(Node2_28_14) V(Node2_28_15) V(Node2_28_16) V(Node2_28_17) V(Node2_28_18) V(Node2_28_19) V(Node2_28_20) V(Node2_28_21) V(Node2_28_22) V(Node2_28_23) V(Node2_28_24) V(Node2_28_25) V(Node2_28_26) V(Node2_28_27) V(Node2_28_28) V(Node2_28_29) V(Node2_28_30) V(Node2_28_31) V(Node2_29_0) V(Node2_29_1) V(Node2_29_2) V(Node2_29_3) V(Node2_29_4) V(Node2_29_5) V(Node2_29_6) V(Node2_29_7) V(Node2_29_8) V(Node2_29_9) V(Node2_29_10) V(Node2_29_11) V(Node2_29_12) V(Node2_29_13) V(Node2_29_14) V(Node2_29_15) V(Node2_29_16) V(Node2_29_17) V(Node2_29_18) V(Node2_29_19) V(Node2_29_20) V(Node2_29_21) V(Node2_29_22) V(Node2_29_23) V(Node2_29_24) V(Node2_29_25) V(Node2_29_26) V(Node2_29_27) V(Node2_29_28) V(Node2_29_29) V(Node2_29_30) V(Node2_29_31) V(Node2_30_0) V(Node2_30_1) V(Node2_30_2) V(Node2_30_3) V(Node2_30_4) V(Node2_30_5) V(Node2_30_6) V(Node2_30_7) V(Node2_30_8) V(Node2_30_9) V(Node2_30_10) V(Node2_30_11) V(Node2_30_12) V(Node2_30_13) V(Node2_30_14) V(Node2_30_15) V(Node2_30_16) V(Node2_30_17) V(Node2_30_18) V(Node2_30_19) V(Node2_30_20) V(Node2_30_21) V(Node2_30_22) V(Node2_30_23) V(Node2_30_24) V(Node2_30_25) V(Node2_30_26) V(Node2_30_27) V(Node2_30_28) V(Node2_30_29) V(Node2_30_30) V(Node2_30_31) V(Node2_31_0) V(Node2_31_1) V(Node2_31_2) V(Node2_31_3) V(Node2_31_4) V(Node2_31_5) V(Node2_31_6) V(Node2_31_7) V(Node2_31_8) V(Node2_31_9) V(Node2_31_10) V(Node2_31_11) V(Node2_31_12) V(Node2_31_13) V(Node2_31_14) V(Node2_31_15) V(Node2_31_16) V(Node2_31_17) V(Node2_31_18) V(Node2_31_19) V(Node2_31_20) V(Node2_31_21) V(Node2_31_22) V(Node2_31_23) V(Node2_31_24) V(Node2_31_25) V(Node2_31_26) V(Node2_31_27) V(Node2_31_28) V(Node2_31_29) V(Node2_31_30) V(Node2_31_31)
.SAVE TYPE=IC
.end
